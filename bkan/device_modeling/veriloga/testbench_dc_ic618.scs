simulator lang=spectre

ahdl_include "<CADENCE_RUN_ROOT>/ge_si_pdet_fixed.va"

parameters Vb_dark=0 Vb_total=0

// Dark current sweep for the current formula model.
Vdark (a_dark 0) vsource dc=Vb_dark
Xdark (a_dark 0) ge_si_photodetector_ic618 active_layer_length=40.0 sim_temp=300.0 trap_assisted_recomb_A=1.0e-9 ge_sio2_recomb_velocity=2500.0 ge_si_recomb_velocity=500.0 area=1.0 light_power=0.0
dc_dark dc param=Vb_dark start=-3 stop=0 step=0.05

// Dark + photocurrent sweep for the current formula model.
Vtotal (a_total 0) vsource dc=Vb_total
Xtotal (a_total 0) ge_si_photodetector_ic618 active_layer_length=40.0 sim_temp=300.0 trap_assisted_recomb_A=1.0e-9 ge_sio2_recomb_velocity=2500.0 ge_si_recomb_velocity=500.0 area=1.0 light_power=1.0
dc_total dc param=Vb_total start=-3 stop=0 step=0.05
