// Locally audited terminal-charge dynamic model for Ge/Si photodetector
// Generated by bkan/device_modeling/terminal_charge/train.py
//
// Qp is fitted to production terminal Q-V values and independently constrained
// by strict two-contact SSAC dQ/dV evidence; Qn = -Qp on this branch.

`include "disciplines.vams"
`include "constants.vams"

module ge_si_photodetector_terminal_charge(anode, cathode);

  inout anode, cathode;
  electrical anode, cathode;

  parameter real active_layer_length = 40.0 from (0.1:100.0);
  parameter real trap_assisted_recomb_A = 1.0e-9 from [0:1.0e-5];
  parameter real ge_sio2_recomb_velocity = 2500.0 from [1.0:1.0e6];
  parameter real ge_si_recomb_velocity = 500.0 from [1.0:1.0e6];
  parameter real sim_temp = 300.0;
  parameter real area = 1.0;
  // Dimensionless selector/scale for the fixed-illumination net-photocurrent branch.
  // Only light_power=0 (dark) and 1 (the characterized illumination) are validated.
  parameter real light_power = 0.0 from [0.0:1.0];
  parameter real v_min = -3.0;
  parameter real v_max = 0.0;
  parameter real smooth_delta = 1.0e-18;
  parameter real sqrt_eps = 1.0e-30;

  real vd, vd_safe, T;
  real dark_current, photo_current, dc_current;
  real q_terminal;

  analog function real smax0;
    input x, delta;
    real x, delta;
    begin
      smax0 = 0.5 * (x + sqrt(x*x + 4.0*delta*delta));
    end
  endfunction

  analog function real sqr;
    input x;
    real x;
    begin
      sqr = x*x;
    end
  endfunction

  analog function real safe_exp_kan;
    input x;
    real x;
    begin
      if (x < -80.0)
        safe_exp_kan = exp(-80.0);
      else if (x < 80.0)
        safe_exp_kan = exp(x);
      else
        safe_exp_kan = exp(80.0) * (1.0 + x - 80.0);
    end
  endfunction

  analog function real safe_sqrt_kan;
    input x, eps, delta;
    real x, eps, delta;
    begin
      safe_sqrt_kan = sqrt(smax0(x, delta) + eps);
    end
  endfunction

  analog function real dark_boundary_gate;
    input v;
    real v, u;
    begin
      if (v <= -2.00000000000000011e-01)
        dark_boundary_gate = 1.0;
      else if (v >= 0.00000000000000000e+00)
        dark_boundary_gate = 0.0;
      else begin
        u = (v - -2.00000000000000011e-01) /
            (0.00000000000000000e+00 - -2.00000000000000011e-01);
        dark_boundary_gate = 1.0 - u*u*(3.0 - 2.0*u);
      end
    end
  endfunction

  analog function real terminal_charge_model;
    input vd_raw, trap_assisted_recomb_A, ge_sio2_recomb_velocity, ge_si_recomb_velocity, active_layer_length, sim_temp;
    real vd_raw, trap_assisted_recomb_A, ge_sio2_recomb_velocity, ge_si_recomb_velocity, active_layer_length, sim_temp;
    real z0, z1, z2, z3, z4;
    real p0, p1, p2, p3, p4, p5;
    real b0, b1, b2, b3, b4, b5, b6, b7, b8, b9, b10, b11, b12, b13;
    real t0, t1, t2, t3, t4, t5, t6, t7, t8, t9, t10;
    real acc;
    begin
      z0 = (trap_assisted_recomb_A - 1.00205806046816974e-09) / 9.56723580081005492e-11;
      z1 = (ge_sio2_recomb_velocity - 2.50344038426073348e+03) / 9.80430525826589871e+01;
      z2 = (ge_si_recomb_velocity - 4.99449941712577072e+02) / 1.82749426344617198e+01;
      z3 = (active_layer_length - 3.99586403701080144e+01) / 1.90790201333369347e+00;
      z4 = (sim_temp - 2.99592878274857867e+02) / 4.75220788418486606e+00;
      p0 = 1.0;
      p1 = z0;
      p2 = z1;
      p3 = z2;
      p4 = z3;
      p5 = z4;
      b0 = vd_raw;
      b1 = vd_raw * vd_raw;
      b2 = b1 * vd_raw;
      if (vd_raw > -2.75000000000000000e+00)
        t0 = vd_raw - -2.75000000000000000e+00;
      else
        t0 = 0.0;
      b3 = t0 * t0 * t0 - 2.07968750000000000e+01;
      if (vd_raw > -2.50000000000000000e+00)
        t1 = vd_raw - -2.50000000000000000e+00;
      else
        t1 = 0.0;
      b4 = t1 * t1 * t1 - 1.56250000000000000e+01;
      if (vd_raw > -2.25000000000000000e+00)
        t2 = vd_raw - -2.25000000000000000e+00;
      else
        t2 = 0.0;
      b5 = t2 * t2 * t2 - 1.13906250000000000e+01;
      if (vd_raw > -2.00000000000000000e+00)
        t3 = vd_raw - -2.00000000000000000e+00;
      else
        t3 = 0.0;
      b6 = t3 * t3 * t3 - 8.00000000000000000e+00;
      if (vd_raw > -1.75000000000000000e+00)
        t4 = vd_raw - -1.75000000000000000e+00;
      else
        t4 = 0.0;
      b7 = t4 * t4 * t4 - 5.35937500000000000e+00;
      if (vd_raw > -1.50000000000000000e+00)
        t5 = vd_raw - -1.50000000000000000e+00;
      else
        t5 = 0.0;
      b8 = t5 * t5 * t5 - 3.37500000000000000e+00;
      if (vd_raw > -1.25000000000000000e+00)
        t6 = vd_raw - -1.25000000000000000e+00;
      else
        t6 = 0.0;
      b9 = t6 * t6 * t6 - 1.95312500000000000e+00;
      if (vd_raw > -1.00000000000000000e+00)
        t7 = vd_raw - -1.00000000000000000e+00;
      else
        t7 = 0.0;
      b10 = t7 * t7 * t7 - 1.00000000000000000e+00;
      if (vd_raw > -7.50000000000000000e-01)
        t8 = vd_raw - -7.50000000000000000e-01;
      else
        t8 = 0.0;
      b11 = t8 * t8 * t8 - 4.21875000000000000e-01;
      if (vd_raw > -5.00000000000000000e-01)
        t9 = vd_raw - -5.00000000000000000e-01;
      else
        t9 = 0.0;
      b12 = t9 * t9 * t9 - 1.25000000000000000e-01;
      if (vd_raw > -2.50000000000000000e-01)
        t10 = vd_raw - -2.50000000000000000e-01;
      else
        t10 = 0.0;
      b13 = t10 * t10 * t10 - 1.56250000000000000e-02;
      acc = 0.0;
      acc = acc + 3.47837548875503277e-01 * b0 * p0;
      acc = acc + 2.35757030117430752e-04 * b0 * p1;
      acc = acc + 3.74914455015297639e-03 * b0 * p2;
      acc = acc + -1.80908329199027480e-03 * b0 * p3;
      acc = acc + 1.79802936251954280e-02 * b0 * p4;
      acc = acc + -2.59321554475388117e-03 * b0 * p5;
      acc = acc + 2.39429580570516498e-01 * b1 * p0;
      acc = acc + -1.31403670111918461e-03 * b1 * p1;
      acc = acc + 2.94667296621857738e-03 * b1 * p2;
      acc = acc + -1.06910467236169364e-03 * b1 * p3;
      acc = acc + 1.30357931092134616e-02 * b1 * p4;
      acc = acc + -3.71958259681445195e-03 * b1 * p5;
      acc = acc + 6.32075569178941893e-02 * b2 * p0;
      acc = acc + -3.24350716335038321e-04 * b2 * p1;
      acc = acc + 5.36396503265021418e-04 * b2 * p2;
      acc = acc + -1.75033166830221298e-04 * b2 * p3;
      acc = acc + 3.34548936169708905e-03 * b2 * p4;
      acc = acc + -6.55618736616155398e-04 * b2 * p5;
      acc = acc + 4.76901354092697627e-01 * b3 * p0;
      acc = acc + -2.99748684915569774e-03 * b3 * p1;
      acc = acc + 3.50071551284725224e-03 * b3 * p2;
      acc = acc + -9.69995886940494545e-04 * b3 * p3;
      acc = acc + 2.51707904021284748e-02 * b3 * p4;
      acc = acc + -4.55265091505610911e-03 * b3 * p5;
      acc = acc + -8.28816864349560256e-01 * b4 * p0;
      acc = acc + 4.96760268735293130e-03 * b4 * p1;
      acc = acc + -6.34941891697128613e-03 * b4 * p2;
      acc = acc + 1.93277702062302770e-03 * b4 * p3;
      acc = acc + -4.38122733073785658e-02 * b4 * p4;
      acc = acc + 8.06633325575558009e-03 * b4 * p5;
      acc = acc + 1.86565281498269564e-01 * b5 * p0;
      acc = acc + -2.80985504263878139e-04 * b5 * p1;
      acc = acc + 1.03954097707588053e-03 * b5 * p2;
      acc = acc + -7.43367287536988997e-04 * b5 * p3;
      acc = acc + 9.89068039442808633e-03 * b5 * p4;
      acc = acc + -2.11729056356634027e-03 * b5 * p5;
      acc = acc + 4.72288209541262216e-01 * b6 * p0;
      acc = acc + -4.93943492550352747e-03 * b6 * p1;
      acc = acc + 5.03402051410184459e-03 * b6 * p2;
      acc = acc + -6.34568839838214882e-04 * b6 * p3;
      acc = acc + 2.48083884948167716e-02 * b6 * p4;
      acc = acc + -3.71516680424258117e-03 * b6 * p5;
      acc = acc + -5.86724921590711435e-01 * b7 * p0;
      acc = acc + 5.55108948181526340e-03 * b7 * p1;
      acc = acc + -6.03808083690210440e-03 * b7 * p2;
      acc = acc + 9.51372509593761961e-04 * b7 * p3;
      acc = acc + -3.07418554422633494e-02 * b7 * p4;
      acc = acc + 4.67427076748033743e-03 * b7 * p5;
      acc = acc + 2.21402242455231713e-02 * b8 * p0;
      acc = acc + -8.03783476865937985e-06 * b8 * p1;
      acc = acc + 1.85805632407082255e-04 * b8 * p2;
      acc = acc + 1.86917894156937714e-05 * b8 * p3;
      acc = acc + 1.15091290633026477e-03 * b8 * p4;
      acc = acc + -9.52878905723375524e-05 * b8 * p5;
      acc = acc + 5.50934910871198724e-01 * b9 * p0;
      acc = acc + -4.92860972368205918e-03 * b9 * p1;
      acc = acc + 5.96062983046037609e-03 * b9 * p2;
      acc = acc + -9.73635424314826803e-04 * b9 * p3;
      acc = acc + 2.88266758440814674e-02 * b9 * p4;
      acc = acc + -4.32520144625447855e-03 * b9 * p5;
      acc = acc + -5.37029229903203786e-01 * b10 * p0;
      acc = acc + 4.10945575927379458e-03 * b10 * p1;
      acc = acc + -6.06797063484662558e-03 * b10 * p2;
      acc = acc + 1.06326312898733649e-03 * b10 * p3;
      acc = acc + -2.79807689904196799e-02 * b10 * p4;
      acc = acc + 3.87650151379145824e-03 * b10 * p5;
      acc = acc + 2.11007458151704907e-01 * b11 * p0;
      acc = acc + -1.02038652180697076e-03 * b11 * p1;
      acc = acc + 2.67286675422780118e-03 * b11 * p2;
      acc = acc + -7.19561019334909180e-04 * b11 * p3;
      acc = acc + 1.07494031877599788e-02 * b11 * p4;
      acc = acc + -1.16067878501176225e-03 * b11 * p5;
      acc = acc + -6.87356537899049685e-03 * b12 * p0;
      acc = acc + -2.89635254597714331e-04 * b12 * p1;
      acc = acc + -5.27675620872712636e-04 * b12 * p2;
      acc = acc + 2.72503429442991912e-04 * b12 * p3;
      acc = acc + -1.94620175968170106e-04 * b12 * p4;
      acc = acc + -3.27295756128449800e-04 * b12 * p5;
      acc = acc + -1.31473984383959436e-01 * b13 * p0;
      acc = acc + -7.34064059127237378e-04 * b13 * p1;
      acc = acc + 5.71591714608330609e-04 * b13 * p2;
      acc = acc + -1.11053399566896777e-04 * b13 * p3;
      acc = acc + -6.00828401727432349e-03 * b13 * p4;
      acc = acc + -3.88550559082372939e-03 * b13 * p5;
      terminal_charge_model = 2.51113537013889362e-15 * acc;
    end
  endfunction
  // BEGIN NET_PHOTOCURRENT_FUNCTION
  // KAN-free student for I_photo,net = I_illum - I_dark.
  analog function real net_pos;
    input x; real x;
    begin if (x > 0.0) net_pos = x; else net_pos = 0.0; end
  endfunction

  analog function real net_clip08;
    input x; real x;
    begin if (x < 0.0) net_clip08 = 0.0; else if (x > 8.0) net_clip08 = 8.0; else net_clip08 = x; end
  endfunction

  analog function real net_sqr;
    input x; real x; begin net_sqr = x*x; end
  endfunction

  analog function real net_softplus;
    input x; real x;
    begin
      if (x > 40.0) net_softplus = x;
      else if (x < -40.0) net_softplus = exp(x);
      else net_softplus = ln(1.0 + exp(x));
    end
  endfunction

  analog function real net_sigmoid;
    input x; real x;
    begin
      if (x >= 0.0) net_sigmoid = 1.0/(1.0 + exp(-x));
      else net_sigmoid = exp(x)/(1.0 + exp(x));
    end
  endfunction

  analog function real net_photocurrent_model;
    input light_voltage, trap_assisted_recomb_A, ge_sio2_recomb_velocity, ge_si_recomb_velocity, active_layer_length, simulation_temperature;
    real light_voltage, trap_assisted_recomb_A, ge_sio2_recomb_velocity, ge_si_recomb_velocity, active_layer_length, simulation_temperature;
    real phi_0, phi_1, phi_2, phi_3, phi_4, phi_5, phi_6, phi_7, phi_8, phi_9, phi_10, phi_11, phi_12, phi_13, phi_14, phi_15, phi_16, phi_17, phi_18, phi_19, phi_20, phi_21, phi_22, phi_23, phi_24, phi_25, phi_26, phi_27, phi_28, photogeneration, field_collection, surface_recombination, trap_recombination, residual, generic, reverse_zero, forward_zero, normalized_output, model_space_output;
    begin
      phi_0 = ((1.0)-(0))/(1); // one
      phi_1 = ((((light_voltage)-(-1.5))/(0.92195444572928875))-(-7.0940586738288403e-10))/(0.99999648332595825); // light_voltage_z
      phi_2 = ((net_sqr(((light_voltage)-(-1.5))/(0.92195444572928875)))-(0.99999302625656128))/(0.88914757966995239); // light_voltage_z2
      phi_3 = ((net_softplus(-light_voltage/0.2))-(7.5757126808166504))/(4.5002450942993164); // soft_reverse_light_voltage
      phi_4 = ((tanh(-light_voltage))-(0.751728355884552))/(0.30399468541145325); // tanh_reverse_light_voltage
      phi_5 = ((1.0-exp(-(net_pos((net_softplus(-light_voltage/0.2))-0.69314718055994529))))-(0.87948030233383179))/(0.26507699489593506); // reverse_saturation_light_voltage
      phi_6 = ((net_sigmoid(light_voltage/0.2))-(0.060259703546762466))/(0.13253849744796753); // forward_gate_light_voltage
      phi_7 = ((net_sigmoid(-light_voltage/0.2))-(0.93974101543426514))/(0.1325385570526123); // reverse_gate_light_voltage
      phi_8 = ((((simulation_temperature)-(299.87142938169382))/(4.7268891282145225))-(1.3969838619232178e-09))/(0.9999997615814209); // temperature_z
      phi_9 = ((1.0/simulation_temperature)-(0.0033355886116623878))/(5.2911309467162937e-05); // inverse_temperature
      phi_10 = ((light_voltage/simulation_temperature)-(-0.0050033912993967533))/(0.0030766816344112158); // light_voltage_over_temperature
      phi_11 = ((((active_layer_length)-(39.869607731989191))/(1.9230349932285624))-(8.4750354290008545e-08))/(1.0000015497207642); // length_z
      phi_12 = ((1.0/active_layer_length)-(0.025140820071101189))/(0.0012282743118703365); // inverse_length
      phi_13 = ((light_voltage/active_layer_length)-(-0.037711285054683685))/(0.023279406130313873); // light_voltage_over_length
      phi_14 = ((((trap_assisted_recomb_A)-(1.0018275180490343e-09))/(9.6309687039470521e-11))-(1.1583324521780014e-08))/(1.0000014305114746); // trap_A_z
      phi_15 = ((((ge_sio2_recomb_velocity)-(2496.5478040463013))/(97.197542229344407))-(-8.2072801887989044e-09))/(0.99999880790710449); // ge_sio2_velocity_z
      phi_16 = ((((ge_si_recomb_velocity)-(500.20451645452926))/(17.970306452827316))-(-2.1187588572502136e-08))/(0.99999964237213135); // ge_si_velocity_z
      phi_17 = ((ge_sio2_recomb_velocity/active_layer_length)-(62.758716583251953))/(3.8315482139587402); // ge_sio2_velocity_over_length
      phi_18 = ((ge_si_recomb_velocity/active_layer_length)-(12.576643943786621))/(0.77762842178344727); // ge_si_velocity_over_length
      phi_19 = (((net_pos((net_softplus(-light_voltage/0.2))-0.69314718055994529))/active_layer_length)-(0.17303270101547241))/(0.11358988285064697); // reverse_drive_over_length
      phi_20 = (((ge_sio2_recomb_velocity+ge_si_recomb_velocity))-(2996.755859375))/(97.873725891113281); // surface_recomb_sum_z
      phi_21 = (((ge_sio2_recomb_velocity+ge_si_recomb_velocity)/active_layer_length)-(75.3353271484375))/(4.3422231674194336); // surface_recomb_over_length
      phi_22 = (((net_pos((net_softplus(-light_voltage/0.2))-0.69314718055994529))*(ge_sio2_recomb_velocity+ge_si_recomb_velocity)/active_layer_length)-(518.49774169921875))/(340.902587890625); // reverse_drive_surface_recomb
      phi_23 = (((net_pos((net_softplus(-light_voltage/0.2))-0.69314718055994529))*trap_assisted_recomb_A)-(6.8951071519052221e-09))/(4.5774961598965547e-09); // reverse_drive_trap_A
      phi_24 = (((1.0-exp(-(net_pos((net_softplus(-light_voltage/0.2))-0.69314718055994529))))*active_layer_length)-(35.064495086669922))/(10.715104103088379); // collection_saturation_length
      phi_25 = ((1.0-exp(-net_pos(active_layer_length)/40.0))-(0.63049399852752686))/(0.017829203978180885); // length_collection_saturation
      phi_26 = (((ge_sio2_recomb_velocity+ge_si_recomb_velocity)/(active_layer_length*simulation_temperature))-(0.25129404664039612))/(0.015141394920647144); // thermal_surface_recomb_over_length
      phi_27 = (((net_pos((net_softplus(-light_voltage/0.2))-0.69314718055994529))*(ge_sio2_recomb_velocity+ge_si_recomb_velocity)/(active_layer_length*simulation_temperature))-(1.7295336723327637))/(1.1377147436141968); // reverse_thermal_surface_recomb
      phi_28 = ((trap_assisted_recomb_A*active_layer_length)-(3.9978072408075604e-08))/(4.5928660874494653e-09); // trap_A_times_length
      reverse_zero = net_pos(net_softplus(-light_voltage/0.20000000000000001)-0.69314718055994529)/14.306852819440055;
      forward_zero = net_pos(net_softplus(light_voltage/0.20000000000000001)-0.69314718055994529)/14.306852819440055;
      photogeneration = (1.0690897703170776)*net_softplus(0.070565812289714813 + (0.046611592173576355)*phi_0 + (0.018446696922183037)*phi_1 + (-0.01358315534889698)*phi_2 + (-0.055834788829088211)*phi_8 + (0.014852904714643955)*phi_9 + (0.0050188079476356506)*phi_10 + (0.016116313636302948)*phi_11 + (0.0037110140547156334)*phi_12 + (0.0027376750949770212)*phi_13 + (-0.018849559128284454)*phi_24 + (-0.019283033907413483)*phi_25)*(1.0);
      field_collection = (0.2708856463432312)*net_softplus(-2.9225237369537354 + (0.050818849354982376)*phi_0 + (-0.079191990196704865)*phi_1 + (0.026402799412608147)*phi_2 + (0.058721497654914856)*phi_3 + (0.075863249599933624)*phi_4 + (0.109133280813694)*phi_5 + (0.065441876649856567)*phi_7 + (-0.058474786579608917)*phi_8 + (0.020511269569396973)*phi_9 + (-0.077710792422294617)*phi_10 + (0.029830966144800186)*phi_11 + (-0.03350478783249855)*phi_12 + (-0.088833659887313843)*phi_13 + (0.092135965824127197)*phi_19 + (0.096487864851951599)*phi_24 + (0.029357168823480606)*phi_25)*(net_sigmoid(4.0*reverse_zero));
      surface_recombination = (0.04257352277636528)*net_softplus(-3.0355315208435059 + (-0.014385473914444447)*phi_0 + (0.051333032548427582)*phi_1 + (0.036047596484422684)*phi_3 + (0.51435816287994385)*phi_8 + (0.23247089982032776)*phi_17 + (0.0067121558822691441)*phi_22 + (-0.038931179791688919)*phi_27)*(net_sigmoid(4.0*reverse_zero));
      trap_recombination = (0.036041177809238434)*net_softplus(-3.0440239906311035 + (-0.031583406031131744)*phi_0 + (0.039414700120687485)*phi_1 + (-0.025164209306240082)*phi_4 + (0.033212203532457352)*phi_10 + (-0.015822052955627441)*phi_19 + (-0.036693606525659561)*phi_23)*(net_sigmoid(4.0*reverse_zero));
      residual = -0.067603632807731628 + (-0.093018084764480591)*phi_0 + (0.0058115636929869652)*phi_1 + (-0.0049644326791167259)*phi_2 + (0.00020143878646194935)*phi_3 + (0.0065452009439468384)*phi_4 + (-0.02372385561466217)*phi_5 + (-0.015203757211565971)*phi_6 + (0.0069154724478721619)*phi_7 + (0.0015629465924575925)*phi_8 + (0.042934298515319824)*phi_9 + (-0.020657788962125778)*phi_10 + (0.018768895417451859)*phi_11 + (-0.00068563030799850821)*phi_12 + (-0.001322719850577414)*phi_13 + (0.00059135298943147063)*phi_14 + (-0.0043415636755526066)*phi_15 + (0.0031439836602658033)*phi_16 + (-0.020888732746243477)*phi_17 + (-0.010461320169270039)*phi_18 + (-0.02332712896168232)*phi_19 + (0.0010256745154038072)*phi_20 + (0.024223349988460541)*phi_21 + (0.021021453663706779)*phi_22 + (-0.00022818251454737037)*phi_23 + (-0.0096869440749287605)*phi_24 + (-0.023290187120437622)*phi_25 + (0.0034513883292675018)*phi_26 + (-0.018460320308804512)*phi_27 + (-0.00039348227437585592)*phi_28;
      generic = 0;
      normalized_output = ((-1)*photogeneration + (-1)*field_collection)*exp(-net_clip08(surface_recombination))*exp(-net_clip08(trap_recombination)) + (0.0) + residual + generic;
      model_space_output = (3.3712586758532748)*normalized_output;
      net_photocurrent_model = pow(10.0, model_space_output);
    end
  endfunction
  // END NET_PHOTOCURRENT_FUNCTION
analog begin
    vd = V(anode, cathode);
    T = sim_temp;

    if (vd < v_min)
      vd_safe = v_min;
    else if (vd > v_max)
      vd_safe = v_max;
    else
      vd_safe = vd;

    // DC source: symbolic KAN formulas from artifacts/results/device_modeling/I-dark-bayes-results/symbolic_formula.txt and artifacts/results/device_modeling/I-photo-bayes-results/symbolic_formula.txt.
    dark_current = dark_boundary_gate(vd_safe) * smax0(pow(10, 0.0041364920460940603*T - 8979627246308360.0*sqr(6.6960677352389096e-10 - safe_exp_kan(-0.068282438309411303*T)) + 4.1655510196711703*sqr(-0.0037685927983991002*T + 1 + 0.35055107291988502/(2.7419450672245702 - 3.99278414053469*vd_safe)) + 11.091804671452*sqr(-0.0036384309408752299*T + 1 + 0.27795067599470802/(2.71809355668523 - 3.91344149021847*vd_safe)) - 4.0797652084980403*sqr(0.0031437998134108301*T - 1 - 0.129413223340552/(1.9810310906033299 - 4.2284055530582396*vd_safe)) - 10.890950950498899*sqr(0.0032060372831007001*T - 1 - 0.067104895549517998/(1.0388148580098799 - 1.47159079721493*vd_safe)) - 7.12316065714458*sqr(0.0032401308694073399*T - 1 - 0.152897530929964/(1.65810271741587 - 4.9512858805121001*vd_safe)) - 7.9153253720267003*sqr(0.0031007692729312099*T + 0.43802923045546699*sqr(1 - 0.027698242091027201*active_layer_length) - 1 - 0.25256010136551499/(2.3734751394050502 - 2.5912779117378402*vd_safe)) - 7.6048937528310399 - 0.146112698632896/(1.21672301165792 - 1.4259479623268201*vd_safe)), smooth_delta);
    photo_current = net_photocurrent_model(vd_safe, trap_assisted_recomb_A, ge_sio2_recomb_velocity, ge_si_recomb_velocity, active_layer_length, T);
    // photo_current is the dark-subtracted net photocurrent I_illum - I_dark.
    dc_current = area * (dark_current + light_power * photo_current);

    q_terminal = area * terminal_charge_model(vd_safe, trap_assisted_recomb_A, ge_sio2_recomb_velocity,
                                                     ge_si_recomb_velocity, active_layer_length, sim_temp);

    I(anode, cathode) <+ dc_current;
    I(anode, cathode) <+ ddt(q_terminal);
  end

endmodule
