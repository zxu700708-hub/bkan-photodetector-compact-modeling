simulator lang=spectre
ahdl_include "ge_si_photodetector_terminal_charge.va"

parameters Vb_dc=0.0 Tdev=300.0
Vdark (a_dark 0) vsource dc=Vb_dc
Vlight (a_light 0) vsource dc=Vb_dc
Vcorner (a_corner 0) vsource dc=Vb_dc
Xdark (a_dark 0) ge_si_photodetector_terminal_charge active_layer_length=40.0 sim_temp=Tdev trap_assisted_recomb_A=1.0e-9 ge_sio2_recomb_velocity=2500.0 ge_si_recomb_velocity=500.0 area=1.0 light_power=0.0
Xlight (a_light 0) ge_si_photodetector_terminal_charge active_layer_length=40.0 sim_temp=Tdev trap_assisted_recomb_A=1.0e-9 ge_sio2_recomb_velocity=2500.0 ge_si_recomb_velocity=500.0 area=1.0 light_power=1.0
Xcorner (a_corner 0) ge_si_photodetector_terminal_charge active_layer_length=43.0 sim_temp=Tdev trap_assisted_recomb_A=1.15e-9 ge_sio2_recomb_velocity=2650.0 ge_si_recomb_velocity=530.0 area=1.0 light_power=1.0
save Vdark:p Vlight:p Vcorner:p
temperature_sweep sweep param=Tdev values=[290.0 300.0 310.0] {
  dc_sparse dc param=Vb_dc start=-3.0 stop=0.0 step=0.05
}
