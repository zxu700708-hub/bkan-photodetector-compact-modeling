simulator lang=spectre
ahdl_include "ge_si_photodetector_terminal_charge.va"

Vstim (pd 0) vsource dc=-1.0 mag=1m type=sine
Xpd001 (pd 0) ge_si_photodetector_terminal_charge active_layer_length=40.0 sim_temp=300.0 trap_assisted_recomb_A=1.0e-9 ge_sio2_recomb_velocity=2500.0 ge_si_recomb_velocity=500.0 area=1.0 light_power=1.0
Xpd002 (pd 0) ge_si_photodetector_terminal_charge active_layer_length=40.0 sim_temp=300.0 trap_assisted_recomb_A=1.0e-9 ge_sio2_recomb_velocity=2500.0 ge_si_recomb_velocity=500.0 area=1.0 light_power=1.0
Xpd003 (pd 0) ge_si_photodetector_terminal_charge active_layer_length=40.0 sim_temp=300.0 trap_assisted_recomb_A=1.0e-9 ge_sio2_recomb_velocity=2500.0 ge_si_recomb_velocity=500.0 area=1.0 light_power=1.0
Xpd004 (pd 0) ge_si_photodetector_terminal_charge active_layer_length=40.0 sim_temp=300.0 trap_assisted_recomb_A=1.0e-9 ge_sio2_recomb_velocity=2500.0 ge_si_recomb_velocity=500.0 area=1.0 light_power=1.0
Xpd005 (pd 0) ge_si_photodetector_terminal_charge active_layer_length=40.0 sim_temp=300.0 trap_assisted_recomb_A=1.0e-9 ge_sio2_recomb_velocity=2500.0 ge_si_recomb_velocity=500.0 area=1.0 light_power=1.0
Xpd006 (pd 0) ge_si_photodetector_terminal_charge active_layer_length=40.0 sim_temp=300.0 trap_assisted_recomb_A=1.0e-9 ge_sio2_recomb_velocity=2500.0 ge_si_recomb_velocity=500.0 area=1.0 light_power=1.0
Xpd007 (pd 0) ge_si_photodetector_terminal_charge active_layer_length=40.0 sim_temp=300.0 trap_assisted_recomb_A=1.0e-9 ge_sio2_recomb_velocity=2500.0 ge_si_recomb_velocity=500.0 area=1.0 light_power=1.0
Xpd008 (pd 0) ge_si_photodetector_terminal_charge active_layer_length=40.0 sim_temp=300.0 trap_assisted_recomb_A=1.0e-9 ge_sio2_recomb_velocity=2500.0 ge_si_recomb_velocity=500.0 area=1.0 light_power=1.0
Xpd009 (pd 0) ge_si_photodetector_terminal_charge active_layer_length=40.0 sim_temp=300.0 trap_assisted_recomb_A=1.0e-9 ge_sio2_recomb_velocity=2500.0 ge_si_recomb_velocity=500.0 area=1.0 light_power=1.0
Xpd010 (pd 0) ge_si_photodetector_terminal_charge active_layer_length=40.0 sim_temp=300.0 trap_assisted_recomb_A=1.0e-9 ge_sio2_recomb_velocity=2500.0 ge_si_recomb_velocity=500.0 area=1.0 light_power=1.0
Xpd011 (pd 0) ge_si_photodetector_terminal_charge active_layer_length=40.0 sim_temp=300.0 trap_assisted_recomb_A=1.0e-9 ge_sio2_recomb_velocity=2500.0 ge_si_recomb_velocity=500.0 area=1.0 light_power=1.0
Xpd012 (pd 0) ge_si_photodetector_terminal_charge active_layer_length=40.0 sim_temp=300.0 trap_assisted_recomb_A=1.0e-9 ge_sio2_recomb_velocity=2500.0 ge_si_recomb_velocity=500.0 area=1.0 light_power=1.0
Xpd013 (pd 0) ge_si_photodetector_terminal_charge active_layer_length=40.0 sim_temp=300.0 trap_assisted_recomb_A=1.0e-9 ge_sio2_recomb_velocity=2500.0 ge_si_recomb_velocity=500.0 area=1.0 light_power=1.0
Xpd014 (pd 0) ge_si_photodetector_terminal_charge active_layer_length=40.0 sim_temp=300.0 trap_assisted_recomb_A=1.0e-9 ge_sio2_recomb_velocity=2500.0 ge_si_recomb_velocity=500.0 area=1.0 light_power=1.0
Xpd015 (pd 0) ge_si_photodetector_terminal_charge active_layer_length=40.0 sim_temp=300.0 trap_assisted_recomb_A=1.0e-9 ge_sio2_recomb_velocity=2500.0 ge_si_recomb_velocity=500.0 area=1.0 light_power=1.0
Xpd016 (pd 0) ge_si_photodetector_terminal_charge active_layer_length=40.0 sim_temp=300.0 trap_assisted_recomb_A=1.0e-9 ge_sio2_recomb_velocity=2500.0 ge_si_recomb_velocity=500.0 area=1.0 light_power=1.0
Xpd017 (pd 0) ge_si_photodetector_terminal_charge active_layer_length=40.0 sim_temp=300.0 trap_assisted_recomb_A=1.0e-9 ge_sio2_recomb_velocity=2500.0 ge_si_recomb_velocity=500.0 area=1.0 light_power=1.0
Xpd018 (pd 0) ge_si_photodetector_terminal_charge active_layer_length=40.0 sim_temp=300.0 trap_assisted_recomb_A=1.0e-9 ge_sio2_recomb_velocity=2500.0 ge_si_recomb_velocity=500.0 area=1.0 light_power=1.0
Xpd019 (pd 0) ge_si_photodetector_terminal_charge active_layer_length=40.0 sim_temp=300.0 trap_assisted_recomb_A=1.0e-9 ge_sio2_recomb_velocity=2500.0 ge_si_recomb_velocity=500.0 area=1.0 light_power=1.0
Xpd020 (pd 0) ge_si_photodetector_terminal_charge active_layer_length=40.0 sim_temp=300.0 trap_assisted_recomb_A=1.0e-9 ge_sio2_recomb_velocity=2500.0 ge_si_recomb_velocity=500.0 area=1.0 light_power=1.0
Xpd021 (pd 0) ge_si_photodetector_terminal_charge active_layer_length=40.0 sim_temp=300.0 trap_assisted_recomb_A=1.0e-9 ge_sio2_recomb_velocity=2500.0 ge_si_recomb_velocity=500.0 area=1.0 light_power=1.0
Xpd022 (pd 0) ge_si_photodetector_terminal_charge active_layer_length=40.0 sim_temp=300.0 trap_assisted_recomb_A=1.0e-9 ge_sio2_recomb_velocity=2500.0 ge_si_recomb_velocity=500.0 area=1.0 light_power=1.0
Xpd023 (pd 0) ge_si_photodetector_terminal_charge active_layer_length=40.0 sim_temp=300.0 trap_assisted_recomb_A=1.0e-9 ge_sio2_recomb_velocity=2500.0 ge_si_recomb_velocity=500.0 area=1.0 light_power=1.0
Xpd024 (pd 0) ge_si_photodetector_terminal_charge active_layer_length=40.0 sim_temp=300.0 trap_assisted_recomb_A=1.0e-9 ge_sio2_recomb_velocity=2500.0 ge_si_recomb_velocity=500.0 area=1.0 light_power=1.0
Xpd025 (pd 0) ge_si_photodetector_terminal_charge active_layer_length=40.0 sim_temp=300.0 trap_assisted_recomb_A=1.0e-9 ge_sio2_recomb_velocity=2500.0 ge_si_recomb_velocity=500.0 area=1.0 light_power=1.0
Xpd026 (pd 0) ge_si_photodetector_terminal_charge active_layer_length=40.0 sim_temp=300.0 trap_assisted_recomb_A=1.0e-9 ge_sio2_recomb_velocity=2500.0 ge_si_recomb_velocity=500.0 area=1.0 light_power=1.0
Xpd027 (pd 0) ge_si_photodetector_terminal_charge active_layer_length=40.0 sim_temp=300.0 trap_assisted_recomb_A=1.0e-9 ge_sio2_recomb_velocity=2500.0 ge_si_recomb_velocity=500.0 area=1.0 light_power=1.0
Xpd028 (pd 0) ge_si_photodetector_terminal_charge active_layer_length=40.0 sim_temp=300.0 trap_assisted_recomb_A=1.0e-9 ge_sio2_recomb_velocity=2500.0 ge_si_recomb_velocity=500.0 area=1.0 light_power=1.0
Xpd029 (pd 0) ge_si_photodetector_terminal_charge active_layer_length=40.0 sim_temp=300.0 trap_assisted_recomb_A=1.0e-9 ge_sio2_recomb_velocity=2500.0 ge_si_recomb_velocity=500.0 area=1.0 light_power=1.0
Xpd030 (pd 0) ge_si_photodetector_terminal_charge active_layer_length=40.0 sim_temp=300.0 trap_assisted_recomb_A=1.0e-9 ge_sio2_recomb_velocity=2500.0 ge_si_recomb_velocity=500.0 area=1.0 light_power=1.0
Xpd031 (pd 0) ge_si_photodetector_terminal_charge active_layer_length=40.0 sim_temp=300.0 trap_assisted_recomb_A=1.0e-9 ge_sio2_recomb_velocity=2500.0 ge_si_recomb_velocity=500.0 area=1.0 light_power=1.0
Xpd032 (pd 0) ge_si_photodetector_terminal_charge active_layer_length=40.0 sim_temp=300.0 trap_assisted_recomb_A=1.0e-9 ge_sio2_recomb_velocity=2500.0 ge_si_recomb_velocity=500.0 area=1.0 light_power=1.0
Xpd033 (pd 0) ge_si_photodetector_terminal_charge active_layer_length=40.0 sim_temp=300.0 trap_assisted_recomb_A=1.0e-9 ge_sio2_recomb_velocity=2500.0 ge_si_recomb_velocity=500.0 area=1.0 light_power=1.0
Xpd034 (pd 0) ge_si_photodetector_terminal_charge active_layer_length=40.0 sim_temp=300.0 trap_assisted_recomb_A=1.0e-9 ge_sio2_recomb_velocity=2500.0 ge_si_recomb_velocity=500.0 area=1.0 light_power=1.0
Xpd035 (pd 0) ge_si_photodetector_terminal_charge active_layer_length=40.0 sim_temp=300.0 trap_assisted_recomb_A=1.0e-9 ge_sio2_recomb_velocity=2500.0 ge_si_recomb_velocity=500.0 area=1.0 light_power=1.0
Xpd036 (pd 0) ge_si_photodetector_terminal_charge active_layer_length=40.0 sim_temp=300.0 trap_assisted_recomb_A=1.0e-9 ge_sio2_recomb_velocity=2500.0 ge_si_recomb_velocity=500.0 area=1.0 light_power=1.0
Xpd037 (pd 0) ge_si_photodetector_terminal_charge active_layer_length=40.0 sim_temp=300.0 trap_assisted_recomb_A=1.0e-9 ge_sio2_recomb_velocity=2500.0 ge_si_recomb_velocity=500.0 area=1.0 light_power=1.0
Xpd038 (pd 0) ge_si_photodetector_terminal_charge active_layer_length=40.0 sim_temp=300.0 trap_assisted_recomb_A=1.0e-9 ge_sio2_recomb_velocity=2500.0 ge_si_recomb_velocity=500.0 area=1.0 light_power=1.0
Xpd039 (pd 0) ge_si_photodetector_terminal_charge active_layer_length=40.0 sim_temp=300.0 trap_assisted_recomb_A=1.0e-9 ge_sio2_recomb_velocity=2500.0 ge_si_recomb_velocity=500.0 area=1.0 light_power=1.0
Xpd040 (pd 0) ge_si_photodetector_terminal_charge active_layer_length=40.0 sim_temp=300.0 trap_assisted_recomb_A=1.0e-9 ge_sio2_recomb_velocity=2500.0 ge_si_recomb_velocity=500.0 area=1.0 light_power=1.0
Xpd041 (pd 0) ge_si_photodetector_terminal_charge active_layer_length=40.0 sim_temp=300.0 trap_assisted_recomb_A=1.0e-9 ge_sio2_recomb_velocity=2500.0 ge_si_recomb_velocity=500.0 area=1.0 light_power=1.0
Xpd042 (pd 0) ge_si_photodetector_terminal_charge active_layer_length=40.0 sim_temp=300.0 trap_assisted_recomb_A=1.0e-9 ge_sio2_recomb_velocity=2500.0 ge_si_recomb_velocity=500.0 area=1.0 light_power=1.0
Xpd043 (pd 0) ge_si_photodetector_terminal_charge active_layer_length=40.0 sim_temp=300.0 trap_assisted_recomb_A=1.0e-9 ge_sio2_recomb_velocity=2500.0 ge_si_recomb_velocity=500.0 area=1.0 light_power=1.0
Xpd044 (pd 0) ge_si_photodetector_terminal_charge active_layer_length=40.0 sim_temp=300.0 trap_assisted_recomb_A=1.0e-9 ge_sio2_recomb_velocity=2500.0 ge_si_recomb_velocity=500.0 area=1.0 light_power=1.0
Xpd045 (pd 0) ge_si_photodetector_terminal_charge active_layer_length=40.0 sim_temp=300.0 trap_assisted_recomb_A=1.0e-9 ge_sio2_recomb_velocity=2500.0 ge_si_recomb_velocity=500.0 area=1.0 light_power=1.0
Xpd046 (pd 0) ge_si_photodetector_terminal_charge active_layer_length=40.0 sim_temp=300.0 trap_assisted_recomb_A=1.0e-9 ge_sio2_recomb_velocity=2500.0 ge_si_recomb_velocity=500.0 area=1.0 light_power=1.0
Xpd047 (pd 0) ge_si_photodetector_terminal_charge active_layer_length=40.0 sim_temp=300.0 trap_assisted_recomb_A=1.0e-9 ge_sio2_recomb_velocity=2500.0 ge_si_recomb_velocity=500.0 area=1.0 light_power=1.0
Xpd048 (pd 0) ge_si_photodetector_terminal_charge active_layer_length=40.0 sim_temp=300.0 trap_assisted_recomb_A=1.0e-9 ge_sio2_recomb_velocity=2500.0 ge_si_recomb_velocity=500.0 area=1.0 light_power=1.0
Xpd049 (pd 0) ge_si_photodetector_terminal_charge active_layer_length=40.0 sim_temp=300.0 trap_assisted_recomb_A=1.0e-9 ge_sio2_recomb_velocity=2500.0 ge_si_recomb_velocity=500.0 area=1.0 light_power=1.0
Xpd050 (pd 0) ge_si_photodetector_terminal_charge active_layer_length=40.0 sim_temp=300.0 trap_assisted_recomb_A=1.0e-9 ge_sio2_recomb_velocity=2500.0 ge_si_recomb_velocity=500.0 area=1.0 light_power=1.0
Xpd051 (pd 0) ge_si_photodetector_terminal_charge active_layer_length=40.0 sim_temp=300.0 trap_assisted_recomb_A=1.0e-9 ge_sio2_recomb_velocity=2500.0 ge_si_recomb_velocity=500.0 area=1.0 light_power=1.0
Xpd052 (pd 0) ge_si_photodetector_terminal_charge active_layer_length=40.0 sim_temp=300.0 trap_assisted_recomb_A=1.0e-9 ge_sio2_recomb_velocity=2500.0 ge_si_recomb_velocity=500.0 area=1.0 light_power=1.0
Xpd053 (pd 0) ge_si_photodetector_terminal_charge active_layer_length=40.0 sim_temp=300.0 trap_assisted_recomb_A=1.0e-9 ge_sio2_recomb_velocity=2500.0 ge_si_recomb_velocity=500.0 area=1.0 light_power=1.0
Xpd054 (pd 0) ge_si_photodetector_terminal_charge active_layer_length=40.0 sim_temp=300.0 trap_assisted_recomb_A=1.0e-9 ge_sio2_recomb_velocity=2500.0 ge_si_recomb_velocity=500.0 area=1.0 light_power=1.0
Xpd055 (pd 0) ge_si_photodetector_terminal_charge active_layer_length=40.0 sim_temp=300.0 trap_assisted_recomb_A=1.0e-9 ge_sio2_recomb_velocity=2500.0 ge_si_recomb_velocity=500.0 area=1.0 light_power=1.0
Xpd056 (pd 0) ge_si_photodetector_terminal_charge active_layer_length=40.0 sim_temp=300.0 trap_assisted_recomb_A=1.0e-9 ge_sio2_recomb_velocity=2500.0 ge_si_recomb_velocity=500.0 area=1.0 light_power=1.0
Xpd057 (pd 0) ge_si_photodetector_terminal_charge active_layer_length=40.0 sim_temp=300.0 trap_assisted_recomb_A=1.0e-9 ge_sio2_recomb_velocity=2500.0 ge_si_recomb_velocity=500.0 area=1.0 light_power=1.0
Xpd058 (pd 0) ge_si_photodetector_terminal_charge active_layer_length=40.0 sim_temp=300.0 trap_assisted_recomb_A=1.0e-9 ge_sio2_recomb_velocity=2500.0 ge_si_recomb_velocity=500.0 area=1.0 light_power=1.0
Xpd059 (pd 0) ge_si_photodetector_terminal_charge active_layer_length=40.0 sim_temp=300.0 trap_assisted_recomb_A=1.0e-9 ge_sio2_recomb_velocity=2500.0 ge_si_recomb_velocity=500.0 area=1.0 light_power=1.0
Xpd060 (pd 0) ge_si_photodetector_terminal_charge active_layer_length=40.0 sim_temp=300.0 trap_assisted_recomb_A=1.0e-9 ge_sio2_recomb_velocity=2500.0 ge_si_recomb_velocity=500.0 area=1.0 light_power=1.0
Xpd061 (pd 0) ge_si_photodetector_terminal_charge active_layer_length=40.0 sim_temp=300.0 trap_assisted_recomb_A=1.0e-9 ge_sio2_recomb_velocity=2500.0 ge_si_recomb_velocity=500.0 area=1.0 light_power=1.0
Xpd062 (pd 0) ge_si_photodetector_terminal_charge active_layer_length=40.0 sim_temp=300.0 trap_assisted_recomb_A=1.0e-9 ge_sio2_recomb_velocity=2500.0 ge_si_recomb_velocity=500.0 area=1.0 light_power=1.0
Xpd063 (pd 0) ge_si_photodetector_terminal_charge active_layer_length=40.0 sim_temp=300.0 trap_assisted_recomb_A=1.0e-9 ge_sio2_recomb_velocity=2500.0 ge_si_recomb_velocity=500.0 area=1.0 light_power=1.0
Xpd064 (pd 0) ge_si_photodetector_terminal_charge active_layer_length=40.0 sim_temp=300.0 trap_assisted_recomb_A=1.0e-9 ge_sio2_recomb_velocity=2500.0 ge_si_recomb_velocity=500.0 area=1.0 light_power=1.0
Xpd065 (pd 0) ge_si_photodetector_terminal_charge active_layer_length=40.0 sim_temp=300.0 trap_assisted_recomb_A=1.0e-9 ge_sio2_recomb_velocity=2500.0 ge_si_recomb_velocity=500.0 area=1.0 light_power=1.0
Xpd066 (pd 0) ge_si_photodetector_terminal_charge active_layer_length=40.0 sim_temp=300.0 trap_assisted_recomb_A=1.0e-9 ge_sio2_recomb_velocity=2500.0 ge_si_recomb_velocity=500.0 area=1.0 light_power=1.0
Xpd067 (pd 0) ge_si_photodetector_terminal_charge active_layer_length=40.0 sim_temp=300.0 trap_assisted_recomb_A=1.0e-9 ge_sio2_recomb_velocity=2500.0 ge_si_recomb_velocity=500.0 area=1.0 light_power=1.0
Xpd068 (pd 0) ge_si_photodetector_terminal_charge active_layer_length=40.0 sim_temp=300.0 trap_assisted_recomb_A=1.0e-9 ge_sio2_recomb_velocity=2500.0 ge_si_recomb_velocity=500.0 area=1.0 light_power=1.0
Xpd069 (pd 0) ge_si_photodetector_terminal_charge active_layer_length=40.0 sim_temp=300.0 trap_assisted_recomb_A=1.0e-9 ge_sio2_recomb_velocity=2500.0 ge_si_recomb_velocity=500.0 area=1.0 light_power=1.0
Xpd070 (pd 0) ge_si_photodetector_terminal_charge active_layer_length=40.0 sim_temp=300.0 trap_assisted_recomb_A=1.0e-9 ge_sio2_recomb_velocity=2500.0 ge_si_recomb_velocity=500.0 area=1.0 light_power=1.0
Xpd071 (pd 0) ge_si_photodetector_terminal_charge active_layer_length=40.0 sim_temp=300.0 trap_assisted_recomb_A=1.0e-9 ge_sio2_recomb_velocity=2500.0 ge_si_recomb_velocity=500.0 area=1.0 light_power=1.0
Xpd072 (pd 0) ge_si_photodetector_terminal_charge active_layer_length=40.0 sim_temp=300.0 trap_assisted_recomb_A=1.0e-9 ge_sio2_recomb_velocity=2500.0 ge_si_recomb_velocity=500.0 area=1.0 light_power=1.0
Xpd073 (pd 0) ge_si_photodetector_terminal_charge active_layer_length=40.0 sim_temp=300.0 trap_assisted_recomb_A=1.0e-9 ge_sio2_recomb_velocity=2500.0 ge_si_recomb_velocity=500.0 area=1.0 light_power=1.0
Xpd074 (pd 0) ge_si_photodetector_terminal_charge active_layer_length=40.0 sim_temp=300.0 trap_assisted_recomb_A=1.0e-9 ge_sio2_recomb_velocity=2500.0 ge_si_recomb_velocity=500.0 area=1.0 light_power=1.0
Xpd075 (pd 0) ge_si_photodetector_terminal_charge active_layer_length=40.0 sim_temp=300.0 trap_assisted_recomb_A=1.0e-9 ge_sio2_recomb_velocity=2500.0 ge_si_recomb_velocity=500.0 area=1.0 light_power=1.0
Xpd076 (pd 0) ge_si_photodetector_terminal_charge active_layer_length=40.0 sim_temp=300.0 trap_assisted_recomb_A=1.0e-9 ge_sio2_recomb_velocity=2500.0 ge_si_recomb_velocity=500.0 area=1.0 light_power=1.0
Xpd077 (pd 0) ge_si_photodetector_terminal_charge active_layer_length=40.0 sim_temp=300.0 trap_assisted_recomb_A=1.0e-9 ge_sio2_recomb_velocity=2500.0 ge_si_recomb_velocity=500.0 area=1.0 light_power=1.0
Xpd078 (pd 0) ge_si_photodetector_terminal_charge active_layer_length=40.0 sim_temp=300.0 trap_assisted_recomb_A=1.0e-9 ge_sio2_recomb_velocity=2500.0 ge_si_recomb_velocity=500.0 area=1.0 light_power=1.0
Xpd079 (pd 0) ge_si_photodetector_terminal_charge active_layer_length=40.0 sim_temp=300.0 trap_assisted_recomb_A=1.0e-9 ge_sio2_recomb_velocity=2500.0 ge_si_recomb_velocity=500.0 area=1.0 light_power=1.0
Xpd080 (pd 0) ge_si_photodetector_terminal_charge active_layer_length=40.0 sim_temp=300.0 trap_assisted_recomb_A=1.0e-9 ge_sio2_recomb_velocity=2500.0 ge_si_recomb_velocity=500.0 area=1.0 light_power=1.0
Xpd081 (pd 0) ge_si_photodetector_terminal_charge active_layer_length=40.0 sim_temp=300.0 trap_assisted_recomb_A=1.0e-9 ge_sio2_recomb_velocity=2500.0 ge_si_recomb_velocity=500.0 area=1.0 light_power=1.0
Xpd082 (pd 0) ge_si_photodetector_terminal_charge active_layer_length=40.0 sim_temp=300.0 trap_assisted_recomb_A=1.0e-9 ge_sio2_recomb_velocity=2500.0 ge_si_recomb_velocity=500.0 area=1.0 light_power=1.0
Xpd083 (pd 0) ge_si_photodetector_terminal_charge active_layer_length=40.0 sim_temp=300.0 trap_assisted_recomb_A=1.0e-9 ge_sio2_recomb_velocity=2500.0 ge_si_recomb_velocity=500.0 area=1.0 light_power=1.0
Xpd084 (pd 0) ge_si_photodetector_terminal_charge active_layer_length=40.0 sim_temp=300.0 trap_assisted_recomb_A=1.0e-9 ge_sio2_recomb_velocity=2500.0 ge_si_recomb_velocity=500.0 area=1.0 light_power=1.0
Xpd085 (pd 0) ge_si_photodetector_terminal_charge active_layer_length=40.0 sim_temp=300.0 trap_assisted_recomb_A=1.0e-9 ge_sio2_recomb_velocity=2500.0 ge_si_recomb_velocity=500.0 area=1.0 light_power=1.0
Xpd086 (pd 0) ge_si_photodetector_terminal_charge active_layer_length=40.0 sim_temp=300.0 trap_assisted_recomb_A=1.0e-9 ge_sio2_recomb_velocity=2500.0 ge_si_recomb_velocity=500.0 area=1.0 light_power=1.0
Xpd087 (pd 0) ge_si_photodetector_terminal_charge active_layer_length=40.0 sim_temp=300.0 trap_assisted_recomb_A=1.0e-9 ge_sio2_recomb_velocity=2500.0 ge_si_recomb_velocity=500.0 area=1.0 light_power=1.0
Xpd088 (pd 0) ge_si_photodetector_terminal_charge active_layer_length=40.0 sim_temp=300.0 trap_assisted_recomb_A=1.0e-9 ge_sio2_recomb_velocity=2500.0 ge_si_recomb_velocity=500.0 area=1.0 light_power=1.0
Xpd089 (pd 0) ge_si_photodetector_terminal_charge active_layer_length=40.0 sim_temp=300.0 trap_assisted_recomb_A=1.0e-9 ge_sio2_recomb_velocity=2500.0 ge_si_recomb_velocity=500.0 area=1.0 light_power=1.0
Xpd090 (pd 0) ge_si_photodetector_terminal_charge active_layer_length=40.0 sim_temp=300.0 trap_assisted_recomb_A=1.0e-9 ge_sio2_recomb_velocity=2500.0 ge_si_recomb_velocity=500.0 area=1.0 light_power=1.0
Xpd091 (pd 0) ge_si_photodetector_terminal_charge active_layer_length=40.0 sim_temp=300.0 trap_assisted_recomb_A=1.0e-9 ge_sio2_recomb_velocity=2500.0 ge_si_recomb_velocity=500.0 area=1.0 light_power=1.0
Xpd092 (pd 0) ge_si_photodetector_terminal_charge active_layer_length=40.0 sim_temp=300.0 trap_assisted_recomb_A=1.0e-9 ge_sio2_recomb_velocity=2500.0 ge_si_recomb_velocity=500.0 area=1.0 light_power=1.0
Xpd093 (pd 0) ge_si_photodetector_terminal_charge active_layer_length=40.0 sim_temp=300.0 trap_assisted_recomb_A=1.0e-9 ge_sio2_recomb_velocity=2500.0 ge_si_recomb_velocity=500.0 area=1.0 light_power=1.0
Xpd094 (pd 0) ge_si_photodetector_terminal_charge active_layer_length=40.0 sim_temp=300.0 trap_assisted_recomb_A=1.0e-9 ge_sio2_recomb_velocity=2500.0 ge_si_recomb_velocity=500.0 area=1.0 light_power=1.0
Xpd095 (pd 0) ge_si_photodetector_terminal_charge active_layer_length=40.0 sim_temp=300.0 trap_assisted_recomb_A=1.0e-9 ge_sio2_recomb_velocity=2500.0 ge_si_recomb_velocity=500.0 area=1.0 light_power=1.0
Xpd096 (pd 0) ge_si_photodetector_terminal_charge active_layer_length=40.0 sim_temp=300.0 trap_assisted_recomb_A=1.0e-9 ge_sio2_recomb_velocity=2500.0 ge_si_recomb_velocity=500.0 area=1.0 light_power=1.0
Xpd097 (pd 0) ge_si_photodetector_terminal_charge active_layer_length=40.0 sim_temp=300.0 trap_assisted_recomb_A=1.0e-9 ge_sio2_recomb_velocity=2500.0 ge_si_recomb_velocity=500.0 area=1.0 light_power=1.0
Xpd098 (pd 0) ge_si_photodetector_terminal_charge active_layer_length=40.0 sim_temp=300.0 trap_assisted_recomb_A=1.0e-9 ge_sio2_recomb_velocity=2500.0 ge_si_recomb_velocity=500.0 area=1.0 light_power=1.0
Xpd099 (pd 0) ge_si_photodetector_terminal_charge active_layer_length=40.0 sim_temp=300.0 trap_assisted_recomb_A=1.0e-9 ge_sio2_recomb_velocity=2500.0 ge_si_recomb_velocity=500.0 area=1.0 light_power=1.0
Xpd100 (pd 0) ge_si_photodetector_terminal_charge active_layer_length=40.0 sim_temp=300.0 trap_assisted_recomb_A=1.0e-9 ge_sio2_recomb_velocity=2500.0 ge_si_recomb_velocity=500.0 area=1.0 light_power=1.0

save Vstim:p pd
multi_100 ac dec=20 start=1M stop=100G
