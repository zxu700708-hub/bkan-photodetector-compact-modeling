simulator lang=spectre
ahdl_include "ge_si_photodetector_terminal_charge.va"

Vstim (pd 0) vsource dc=-1.0 mag=1m type=sine
Xpd001 (pd 0) ge_si_photodetector_terminal_charge active_layer_length=40.0 sim_temp=300.0 trap_assisted_recomb_A=1.0e-9 ge_sio2_recomb_velocity=2500.0 ge_si_recomb_velocity=500.0 area=1.0 light_power=1.0

save Vstim:p pd
multi_001 ac dec=20 start=1M stop=100G
