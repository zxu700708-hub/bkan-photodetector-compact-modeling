// Frozen physics_balanced_sparse_v1 seed-42 10/8/20 candidate.
// Only the characterized illumination endpoints and area=1 are validated.
`include "disciplines.vams"
`include "constants.vams"

module ge_si_photodetector_terminal_charge(anode, cathode);
  inout anode, cathode;
  electrical anode, cathode;
  parameter real active_layer_length=40.0 from [34.83:44.83];
  parameter real trap_assisted_recomb_A=1.0e-9 from [7.52e-10:1.26e-9];
  parameter real ge_sio2_recomb_velocity=2500.0 from [2276.0:2767.0];
  parameter real ge_si_recomb_velocity=500.0 from [454.0:547.0];
  parameter real sim_temp=300.0 from [285.18:311.33];
  parameter real area=1.0 from (0:1.0e6];
  parameter real light_power=0.0 from [0:1];
  real vd, vd_safe, q_terminal;

  analog function real sparse_pos;
    input x;
    real x;
    begin
      if (x > 0.0) sparse_pos = x;
      else sparse_pos = 0.0;
    end
  endfunction

  analog function real sparse_dark;
    input dark_voltage, trap_assisted_recomb_A, ge_sio2_recomb_velocity, ge_si_recomb_velocity, active_layer_length, simulation_temperature;
    real dark_voltage, trap_assisted_recomb_A, ge_sio2_recomb_velocity, ge_si_recomb_velocity, active_layer_length, simulation_temperature;
    begin
      sparse_dark = pow(10.0,
        -6.415199522159571
        + (-0.0084845597753956496)*((((((trap_assisted_recomb_A-(9.9733969135206068e-10))/9.8988482369356346e-11)))-(-5.8639435899602674e-16))/0.999999999999999)
        + (0.013179387623192611)*((((((ge_sio2_recomb_velocity-(2504.0379557560577))/99.528948770076752)))-(-1.2799946288074201e-15))/1)
        + (-7.1926703021981696e-05)*((((((ge_si_recomb_velocity-(500.07777069883736))/18.384142134304081)))-(-5.3123376646720582e-16))/1.0000000000000033)
        + (0.021031889939394654)*((((((active_layer_length-(39.885518313380729))/1.9155696527908814)))-(6.6788660828727886e-16))/1.0000000000000016)
        + (0.12837628100864318)*((((((simulation_temperature-(299.69744215872004))/4.7391438151593039)))-(4.3248680100157109e-15))/1.000000000000002)
        + (-0.044762430943805054)*((((((dark_voltage-(-1.6000000000000001))/0.86409875978771478)))-(-1.6201851746019649))/0.99999999999999967)
        + (-0.059792171361209359)*(((((sparse_pos(((dark_voltage-(-1.6000000000000001))/0.86409875978771478)-(-1.1572751247156892)))*(sparse_pos(((dark_voltage-(-1.6000000000000001))/0.86409875978771478)-(-1.1572751247156892)))*(sparse_pos(((dark_voltage-(-1.6000000000000001))/0.86409875978771478)-(-1.1572751247156892)))))-(0))/6.6142505550151798)
        + (-0.017659702410913407)*(((((sparse_pos(((dark_voltage-(-1.6000000000000001))/0.86409875978771478)-(0.69436507482941368)))*(sparse_pos(((dark_voltage-(-1.6000000000000001))/0.86409875978771478)-(0.69436507482941368)))*(sparse_pos(((dark_voltage-(-1.6000000000000001))/0.86409875978771478)-(0.69436507482941368)))))-(0))/0.20805678924519674)
        + (-0.0090440099136584167)*(((((sparse_pos(((dark_voltage-(-1.6000000000000001))/0.86409875978771478)-(1.1572751247156892)))*(sparse_pos(((dark_voltage-(-1.6000000000000001))/0.86409875978771478)-(1.1572751247156892)))*(sparse_pos(((dark_voltage-(-1.6000000000000001))/0.86409875978771478)-(1.1572751247156892)))))-(0))/0.02471595193156401));
    end
  endfunction

  analog function real sparse_photo;
    input light_voltage, trap_assisted_recomb_A, ge_sio2_recomb_velocity, ge_si_recomb_velocity, active_layer_length, simulation_temperature;
    real light_voltage, trap_assisted_recomb_A, ge_sio2_recomb_velocity, ge_si_recomb_velocity, active_layer_length, simulation_temperature;
    begin
      sparse_photo = pow(10.0,
        -3.2802730309732433
        + (0.00090031155323575082)*((((((trap_assisted_recomb_A-(1.0018275180490343e-09))/9.6309687039470547e-11)))-(-4.7184478546569153e-16))/1.0000000000000011)
        + (-0.002670378312737808)*((((((ge_sio2_recomb_velocity-(2496.5478040463013))/97.197542229344407)))-(3.1182738682855593e-15))/0.99999999999999822)
        + (0.00039591138771209478)*((((((ge_si_recomb_velocity-(500.20451645452926))/17.970306452827316)))-(-4.8214470610430382e-16))/1.0000000000000009)
        + (0.0045698953420800926)*((((((active_layer_length-(39.869607731989191))/1.9230349932285624)))-(1.4499577753734894e-15))/0.99999999999999845)
        + (-0.0013154115054173055)*((((((simulation_temperature-(299.87142938169382))/4.7268891282145225)))-(-5.1209579111921588e-15))/0.99999999999999922)
        + (-0.0085236125896784119)*((((((light_voltage-(-1.5))/0.92195444572928875)))-(-1.6269784336399213))/1.0000000000000007)
        + (-0.014130481679069709)*(((((sparse_pos(((light_voltage-(-1.5))/0.92195444572928875)-(-1.193117518002609)))*(sparse_pos(((light_voltage-(-1.5))/0.92195444572928875)-(-1.193117518002609)))*(sparse_pos(((light_voltage-(-1.5))/0.92195444572928875)-(-1.193117518002609)))))-(0))/6.8845021634591026));
    end
  endfunction

  analog function real sparse_charge;
    input bias_v, trap_assisted_recomb_A, ge_sio2_recomb_velocity, ge_si_recomb_velocity, active_layer_length, simulation_temperature;
    real bias_v, trap_assisted_recomb_A, ge_sio2_recomb_velocity, ge_si_recomb_velocity, active_layer_length, simulation_temperature;
    begin
      sparse_charge = 2.508803408616369e-15 * (
        (23.07314621636716)*(bias_v)
        + (-4.3960992262985901e-05)*(bias_v*((trap_assisted_recomb_A-(1.0044324391819921e-09))/1.026005155189889e-10))
        + (3.1669357622021749e-06)*(bias_v*((ge_sio2_recomb_velocity-(2503.2512496664453))/100.79419192741712))
        + (5.5952216359731816e-05)*(bias_v*((ge_si_recomb_velocity-(498.3319450592557))/18.150735942170922))
        + (0.063318580513463923)*(bias_v*((active_layer_length-(39.960577004428941))/1.9294436311499816))
        + (0.00025517947205873527)*(bias_v*((simulation_temperature-(299.54063890361334))/4.773521403821622))
        + (8.1951432686175263)*(bias_v*bias_v)
        + (0.024032457224506233)*(bias_v*bias_v*((active_layer_length-(39.960577004428941))/1.9294436311499816))
        + (-0.000455919052513829)*(bias_v*bias_v*((simulation_temperature-(299.54063890361334))/4.773521403821622))
        + (0.98951270945294711)*(bias_v*bias_v*bias_v)
        + (0.0041537114674513112)*(bias_v*bias_v*bias_v*((active_layer_length-(39.960577004428941))/1.9294436311499816))
        + (-1.0667416241012917)*((((sparse_pos(bias_v-(-2.75)))*(sparse_pos(bias_v-(-2.75)))*(sparse_pos(bias_v-(-2.75))))-20.796875))
        + (0.389819511730156)*((((sparse_pos(bias_v-(-2)))*(sparse_pos(bias_v-(-2)))*(sparse_pos(bias_v-(-2))))-8))
        + (-0.51159212214107863)*((((sparse_pos(bias_v-(-1.75)))*(sparse_pos(bias_v-(-1.75)))*(sparse_pos(bias_v-(-1.75))))-5.359375))
        + (-0.0086992497099491282)*((((sparse_pos(bias_v-(-1.75)))*(sparse_pos(bias_v-(-1.75)))*(sparse_pos(bias_v-(-1.75))))-5.359375)*((active_layer_length-(39.960577004428941))/1.9294436311499816))
        + (0.6072706327221401)*((((sparse_pos(bias_v-(-1.25)))*(sparse_pos(bias_v-(-1.25)))*(sparse_pos(bias_v-(-1.25))))-1.953125))
        + (0.0055366859208176222)*((((sparse_pos(bias_v-(-1.25)))*(sparse_pos(bias_v-(-1.25)))*(sparse_pos(bias_v-(-1.25))))-1.953125)*((active_layer_length-(39.960577004428941))/1.9294436311499816))
        + (-0.69510223822614314)*((((sparse_pos(bias_v-(-1)))*(sparse_pos(bias_v-(-1)))*(sparse_pos(bias_v-(-1))))-1))
        + (0.4280007941070717)*((((sparse_pos(bias_v-(-0.75)))*(sparse_pos(bias_v-(-0.75)))*(sparse_pos(bias_v-(-0.75))))-0.421875))
        + (-0.19667754155916242)*((((sparse_pos(bias_v-(-0.5)))*(sparse_pos(bias_v-(-0.5)))*(sparse_pos(bias_v-(-0.5))))-0.125)));
    end
  endfunction

  analog begin
    vd = V(anode, cathode);
    if (vd < -3.0) vd_safe = -3.0;
    else if (vd > 0.0) vd_safe = 0.0;
    else vd_safe = vd;
    q_terminal = area * sparse_charge(vd_safe, trap_assisted_recomb_A, ge_sio2_recomb_velocity, ge_si_recomb_velocity, active_layer_length, sim_temp);
    I(anode, cathode) <+ area * (sparse_dark(vd_safe, trap_assisted_recomb_A, ge_sio2_recomb_velocity, ge_si_recomb_velocity, active_layer_length, sim_temp) + light_power * sparse_photo(vd_safe, trap_assisted_recomb_A, ge_sio2_recomb_velocity, ge_si_recomb_velocity, active_layer_length, sim_temp));
    I(anode, cathode) <+ ddt(q_terminal);
  end
endmodule
