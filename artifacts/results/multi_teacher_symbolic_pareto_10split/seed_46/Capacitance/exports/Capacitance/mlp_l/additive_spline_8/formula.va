`include "constants.vams"
`include "disciplines.vams"
module spline_ridge_export(out);
output out; electrical out;
parameter real x0=0.0; // bias_v
parameter real x1=0.0; // log_frequency_ghz
parameter real x2=0.0; // trap_assisted_recomb_A
parameter real x3=0.0; // ge_sio2_recomb_velocity
parameter real x4=0.0; // ge_si_recomb_velocity
parameter real x5=0.0; // active_layer_length
parameter real x6=0.0; // simulation_temperature
real y,z,g;
analog begin
  y = 4.7987866560741553e-14;
  z = (x0--1.5)/0.92195444572928875;
  z = min(max(z,-1.6269784336399213),1.6269784336399213);
  if (z < -2.5566803957198765) begin
    g = ((((((-2.4705478886449406e-18)*(z--3.0215313767598539)+4.6182805921823774e-17))*(z--3.0215313767598539)+-1.8379206018206037e-16))*(z--3.0215313767598539)+-1.8335755715535579e-14);
  end
  else if (z < -2.091829414679899) begin
    g = ((((((-2.4705478886449406e-18)*(z--2.5566803957198765)+4.2737496092595231e-17))*(z--2.5566803957198765)+-1.4245737055628647e-16))*(z--2.5566803957198765)+-1.8411460318720663e-14);
  end
  else if (z < -1.6269784336399213) begin
    g = ((((((-2.4705478886449406e-18)*(z--2.091829414679899)+3.9292186263366688e-17))*(z--2.091829414679899)+-1.0432579223871979e-16))*(z--2.091829414679899)+-1.8468694935599198e-14);
  end
  else if (z < -1.1621274525999439) begin
    g = ((((((-2.4705478886449406e-18)*(z--1.6269784336399213)+3.5846876434138151e-17))*(z--1.6269784336399213)+-6.9397325229360265e-17))*(z--1.6269784336399213)+-1.8508948535605213e-14);
  end
  else if (z < -0.6972764715599663) begin
    g = ((((((3.9845173640206194e-17)*(z--1.1621274525999439)+3.2401566604909614e-17))*(z--1.1621274525999439)+-3.7671969528207894e-17))*(z--1.1621274525999439)+-1.8533710088172699e-14);
  end
  else if (z < -0.23242549051998873) begin
    g = ((((((1.9847770099917311e-16)*(z--0.6972764715599663)+8.7967770773983923e-17))*(z--0.6972764715599663)+1.8281835039502802e-17))*(z--0.6972764715599663)+-1.8540218033516107e-14);
  end
  else if (z < 0.23242549051998873) begin
    g = ((((((5.1718361359767559e-16)*(z--0.23242549051998873)+3.6475543284605875e-16))*(z--0.23242549051998873)+2.2873066038184117e-16))*(z--0.23242549051998873)+-1.8492774376275094e-14);
  end
  else if (z < 0.69727647155996642) begin
    g = ((((((2.2643501449285116e-15)*(z-0.23242549051998873)+1.0859953633220991e-15))*(z-0.23242549051998873)+9.0311359122513761e-16))*(z-0.23242549051998873)+-1.8255679948411252e-14);
  end
  else if (z < 1.1621274525999439) begin
    g = ((((((3.6141459516079941e-15)*(z-0.69727647155996642)+4.2437515221862019e-15))*(z-0.69727647155996642)+3.3806516596484373e-15))*(z-0.69727647155996642)+-1.7373748420308227e-14);
  end
  else if (z < 1.6269784336399213) begin
    g = ((((((-3.0245133667979115e-15)*(z-1.1621274525999439)+9.283869395866118e-15))*(z-1.1621274525999439)+9.6689795145419791e-15))*(z-1.1621274525999439)+-1.4522198343734641e-14);
  end
  else if (z < 2.091829414679899) begin
    g = ((((((-3.0245133667979115e-15)*(z-1.6269784336399213)+5.0660253786925152e-15))*(z-1.6269784336399213)+1.6339542178316006e-14))*(z-1.6269784336399213)+-8.3252517856957546e-15);
  end
  else if (z < 2.5566803957198765) begin
    g = ((((((-3.0245133667979115e-15)*(z-2.091829414679899)+8.4818136151890913e-16))*(z-2.091829414679899)+1.9088766983576533e-14))*(z-2.091829414679899)+6.109349542753395e-17);
  end
  else begin
    g = ((((((-3.0245133667979115e-15)*(z-2.5566803957198765)+-3.3696626556546922e-15))*(z-2.5566803957198765)+1.7916653930323574e-14))*(z-2.5566803957198765)+8.8139997491160246e-15);
  end
  y = y + g;
  z = (x1-0.19604119982655921)/0.71475520981330376;
  z = min(max(z,-1.6733577921579177),1.5459681589813783);
  if (z < -2.5931652067691453) begin
    g = ((((((-3.0754551999158319e-17)*(z--3.0530689140747591)+-5.1960925651739418e-17))*(z--3.0530689140747591)+7.718707059118337e-16))*(z--3.0530689140747591)+1.0399860849640623e-15);
  end
  else if (z < -2.1332614994635315) begin
    g = ((((((-3.0754551999158319e-17)*(z--2.5931652067691453)+-9.4393323094547982e-17))*(z--2.5931652067691453)+7.0456184433348828e-16))*(z--2.5931652067691453)+1.3809903094591324e-15);
  end
  else if (z < -1.6733577921579177) begin
    g = ((((((-3.0754551999158319e-17)*(z--2.1332614994635315)+-1.3682572053735652e-16))*(z--2.1332614994635315)+5.9822334896751683e-16))*(z--2.1332614994635315)+1.6820640023429386e-15);
  end
  else if (z < -1.2134540848523039) begin
    g = ((((((-3.0754551999158319e-17)*(z--1.6733577921579177)+-1.7925811798016509e-16))*(z--1.6733577921579177)+4.5285521981391964e-16))*(z--1.6733577921579177)+1.9252572903417785e-15);
  end
  else if (z < -0.7535503775466903) begin
    g = ((((((-3.7801169658670817e-17)*(z--1.2134540848523039)+-2.2169051542297365e-16))*(z--1.2134540848523039)+2.6845745687269672e-16))*(z--1.2134540848523039)+2.0926203001819429e-15);
  end
  else if (z < -0.29364667024107671) begin
    g = ((((((-2.3376276540751486e-17)*(z--0.7535503775466903)+-2.7384520962250721e-16))*(z--0.7535503775466903)+4.0558739821904887e-17))*(z--0.7535503775466903)+2.1655176996588513e-15);
  end
  else if (z < 0.16625703706453709) begin
    g = ((((((-1.8045326307984462e-17)*(z--0.29364667024107671)+-3.0609771835478577e-16))*(z--0.29364667024107671)+-2.2615916278052457e-16))*(z--0.29364667024107671)+2.1239755006808243e-15);
  end
  else if (z < 0.6261607443701509) begin
    g = ((((((1.1295581506033382e-17)*(z-0.16625703706453709)+-3.309950557605305e-16))*(z-0.16625703706453709)+-5.1916049149377651e-16))*(z-0.16625703706453709)+1.9534655431480372e-15);
  end
  else if (z < 1.0860644516757643) begin
    g = ((((((4.4962648857814934e-18)*(z-0.6261607443701509)+-3.1541041632813806e-16))*(z-0.6261607443701509)+-8.164447645299908e-16))*(z-0.6261607443701509)+1.6457912505742016e-15);
  end
  else if (z < 1.5459681589813783) begin
    g = ((((((8.7334045498290726e-17)*(z-1.0860644516757643)+-3.0920686965814118e-16))*(z-1.0860644516757643)+-1.1037085700022508e-15))*(z-1.0860644516757643)+1.2040297451733672e-15);
  end
  else if (z < 2.0058718662869923) begin
    g = ((((((8.7334045498290726e-17)*(z-1.5459681589813783)+-1.8871111576215795e-16))*(z-1.5459681589813783)+-1.3327028974311893e-15))*(z-1.5459681589813783)+6.3952470730780521e-16);
  end
  else if (z < 2.4657755735926061) begin
    g = ((((((8.7334045498290726e-17)*(z-2.0058718662869923)+-6.8215361866174716e-17))*(z-2.0058718662869923)+-1.4508643369974326e-15))*(z-2.0058718662869923)+-4.8094426845604923e-18);
  end
  else begin
    g = ((((((8.7334045498290726e-17)*(z-2.4657755735926061)+5.2280392029808492e-17))*(z-2.4657755735926061)+-1.4581928887009808e-15))*(z-2.4657755735926061)+-6.7800024878428915e-16);
  end
  y = y + g;
  z = (x2-1.0043431072598764e-09)/9.6517718030773918e-11;
  z = min(max(z,-2.6181138531925741),2.4784336805081066);
  if (z < -4.0742702913927689) begin
    g = ((((((-8.4636187013800165e-17)*(z--4.802348510492866)+6.9316280642946861e-16))*(z--4.802348510492866)+-1.861618657784813e-15))*(z--4.802348510492866)+1.6297352072804202e-15);
  end
  else if (z < -3.3461920722926712) begin
    g = ((((((-8.4636187013800165e-17)*(z--4.0742702913927689)+5.0829751349217743e-16))*(z--4.0742702913927689)+-9.8686156773682782e-16))*(z--4.0742702913927689)+6.0910978612702456e-16);
  end
  else if (z < -2.6181138531925741) begin
    g = ((((((-8.4636187013800165e-17)*(z--3.3461920722926712)+3.234322205548861e-16))*(z--3.3461920722926712)+-3.8129726419924377e-16))*(z--3.3461920722926712)+1.273792469424058e-16);
  end
  else if (z < -1.8900356340924769) begin
    g = ((((((-8.4636187013800165e-17)*(z--2.6181138531925741)+1.3856692761759492e-16))*(z--2.6181138531925741)+-4.4925747172061892e-17))*(z--2.6181138531925741)+-1.1449814870520709e-17);
  end
  else if (z < -1.1619574149923795) begin
    g = ((((((3.3713908729430546e-17)*(z--1.8900356340924769)+-4.6298365319696261e-17))*(z--1.8900356340924769)+2.2252983344718531e-17))*(z--1.8900356340924769)+-3.3708039088415251e-18);
  end
  else if (z < -0.43387919589228208) begin
    g = ((((((-2.0064540834258943e-17)*(z--1.1619574149923795)+2.7340722560184796e-17))*(z--1.1619574149923795)+8.4503365660375681e-18))*(z--1.1619574149923795)+1.3004177755353499e-18);
  end
  else if (z < 0.2941990232078151) begin
    g = ((((((6.3436527582932731e-18)*(z--0.43387919589228208)+-1.6484942912820504e-17))*(z--0.43387919589228208)+1.6354193278633644e-17))*(z--0.43387919589228208)+1.4202218888358952e-17);
  end
  else if (z < 1.0222772423079123) begin
    g = ((((((7.8737227177450022e-18)*(z-0.2941990232078151)+-2.628916704277747e-18))*(z-0.2941990232078151)+2.4378084084874861e-18))*(z-0.2941990232078151)+1.9819067399155799e-17);
  end
  else if (z < 1.7503554614080099) begin
    g = ((((((-2.0507689829560506e-17)*(z-1.0222772423079123)+1.4569141337793528e-17))*(z-1.0222772423079123)+1.1131225895312766e-17))*(z-1.0222772423079123)+2.3239284175566219e-17);
  end
  else if (z < 2.4784336805081066) begin
    g = ((((((1.2084469123861217e-17)*(z-1.7503554614080099)+-3.022446552909726e-17))*(z-1.7503554614080099)+-2.6707466132633226e-19))*(z-1.7503554614080099)+3.1151759554427272e-17);
  end
  else if (z < 3.2065118996082034) begin
    g = ((((((1.2084469123861217e-17)*(z-2.4784336805081066)+-3.829149253684318e-18))*(z-2.4784336805081066)+-2.5060769866294672e-17))*(z-2.4784336805081066)+1.9599416661429589e-17);
  end
  else if (z < 3.9345901187083001) begin
    g = ((((((1.2084469123861217e-17)*(z-3.2065118996082034)+2.2566167021728624e-17))*(z-3.2065118996082034)+-1.14187553384901e-17))*(z-3.2065118996082034)+3.9874258647307239e-18);
  end
  else begin
    g = ((((((1.2084469123861217e-17)*(z-3.9345901187083001)+4.8961483297141568e-17))*(z-3.9345901187083001)+4.0658968922087386e-17))*(z-3.9345901187083001)+1.2299990256416229e-17);
  end
  y = y + g;
  z = (x3-2504.5660673141692)/92.945339418347672;
  z = min(max(z,-2.1724588215989433),2.8202148291337421);
  if (z < -3.5989370075225677) begin
    g = ((((((-5.4332214763885724e-17)*(z--4.3121761004843799)+4.5142362885934301e-16))*(z--4.3121761004843799)+-1.2456293504591259e-15))*(z--4.3121761004843799)+1.1033621701065215e-15);
  end
  else if (z < -2.8856979145607555) begin
    g = ((((((-5.4332214763885724e-17)*(z--3.5989370075225677)+3.3516805012894236e-16))*(z--3.5989370075225677)+-6.8460141480621234e-16))*(z--3.5989370075225677)+4.2486087930901371e-16);
  end
  else if (z < -2.1724588215989433) begin
    g = ((((((-5.4332214763885724e-17)*(z--2.8856979145607555)+2.1891247139854166e-16))*(z--2.8856979145607555)+-2.8940952620414178e-16))*(z--2.8856979145607555)+8.7366268573370182e-17);
  end
  else if (z < -1.4592197286371311) begin
    g = ((((((-5.4332214763885724e-17)*(z--2.1724588215989433)+1.0265689266814097e-16))*(z--2.1724588215989433)+-6.0053684652914316e-17))*(z--2.1724588215989433)+-2.7402413879324802e-17);
  end
  else if (z < -0.74598063567531891) begin
    g = ((((((9.0534805015021097e-18)*(z--1.4592197286371311)+-1.3598686062259717e-17))*(z--1.4592197286371311)+3.4661098474701041e-18))*(z--1.4592197286371311)+-3.7725919827987018e-17);
  end
  else if (z < -0.032741542713506711) begin
    g = ((((((1.2729967220532084e-18)*(z--0.74598063567531891)+5.7732026008567363e-18))*(z--0.74598063567531891)+-2.115330878528621e-18))*(z--0.74598063567531891)+-3.8886651237029081e-17);
  end
  else if (z < 0.68049755024830549) begin
    g = ((((((-1.1588380421316085e-17)*(z--0.032741542713506711)+8.4970556829985078e-18))*(z--0.032741542713506711)+8.0627751961790789e-18))*(z--0.032741542713506711)+-3.6996618227010398e-17);
  end
  else if (z < 1.3937366432101177) begin
    g = ((((((7.4267882642346603e-18)*(z-0.68049755024830549)+-1.6298802138789211e-17))*(z-0.68049755024830549)+2.498264630532886e-18))*(z-0.68049755024830549)+-3.1128028172810737e-17);
  end
  else if (z < 2.1069757361719299) begin
    g = ((((((6.4378263229013114e-18)*(z-1.3937366432101177)+-4.0757496318273062e-19))*(z-1.3937366432101177)+-9.4173766203555688e-18))*(z-1.3937366432101177)+-3.4942856458632063e-17);
  end
  else if (z < 2.8202148291337421) begin
    g = ((((((6.8190590890731639e-18)*(z-2.1069757361719299)+1.3367553258392699e-17))*(z-2.1069757361719299)+-1.7381345627523821e-19))*(z-2.1069757361719299)+-3.9531186568799794e-17);
  end
  else if (z < 3.5334539220955543) begin
    g = ((((((6.8190590890731639e-18)*(z-2.8202148291337421)+2.7958411817023332e-17))*(z-2.8202148291337421)+2.9301480389886023e-17))*(z-2.8202148291337421)+-3.0380777148850323e-17);
  end
  else if (z < 4.2466930150573665) begin
    g = ((((((6.8190590890731639e-18)*(z-3.5334539220955543)+4.2549270375653965e-17))*(z-3.5334539220955543)+7.9590315683830899e-17))*(z-3.5334539220955543)+7.2150798304882267e-18);
  end
  else begin
    g = ((((((6.8190590890731639e-18)*(z-4.2466930150573665)+5.7140128934284592e-17))*(z-4.2466930150573665)+1.5069269242555938e-16))*(z-4.2466930150573665)+8.8101415792756136e-17);
  end
  y = y + g;
  z = (x4-498.63648094610454)/18.636632711054482;
  z = min(max(z,-2.3738669226359939),2.6081817926661524);
  if (z < -3.7973094127223215) begin
    g = ((((((3.7519110354327894e-16)*(z--4.5090306577654857)+-3.083647417630237e-15))*(z--4.5090306577654857)+8.348795007502638e-15))*(z--4.5090306577654857)+-7.3262595869128135e-15);
  end
  else if (z < -3.0855881676791577) begin
    g = ((((((3.7519110354327894e-16)*(z--3.7973094127223215)+-2.2825529796014129e-15))*(z--3.7973094127223215)+4.5295561796338053e-15))*(z--3.7973094127223215)+-2.8109935312335159e-15);
  end
  else if (z < -2.3738669226359939) begin
    g = ((((((3.7519110354327894e-16)*(z--3.0855881676791577)+-1.4814585415725894e-15))*(z--3.0855881676791577)+1.8506292134270315e-15))*(z--3.0855881676791577)+-6.0816880028241654e-16);
  end
  else if (z < -1.6621456775928301) begin
    g = ((((((3.7519110354327894e-16)*(z--2.3738669226359939)+-6.8036410354376605e-16))*(z--2.3738669226359939)+3.1201410888231304e-16))*(z--2.3738669226359939)+9.379878386009492e-17);
  end
  else if (z < -0.95042443254966646) begin
    g = ((((((-5.5539778162455549e-17)*(z--1.6621456775928301)+1.2073033448505729e-16))*(z--1.6621456775928301)+-8.6289134000349533e-17))*(z--1.6621456775928301)+1.0649339911362504e-16);
  end
  else if (z < -0.23870318750650288) begin
    g = ((((((-2.5289297605379273e-18)*(z--0.95042443254966646)+2.1438142954454055e-18))*(z--0.95042443254966646)+1.1630081533287551e-18))*(z--0.95042443254966646)+8.6211973232739888e-17);
  end
  else if (z < 0.47301805753666093) begin
    g = ((((((3.8070811563594825e-19)*(z--0.23870318750650288)+-3.2558648179448841e-18))*(z--0.23870318750650288)+3.7153817090452615e-19))*(z--0.23870318750650288)+8.72139231698524e-17);
  end
  else if (z < 1.1847393025798247) begin
    g = ((((((1.635425140701959e-19)*(z-0.47301805753666093)+-2.4429906557695225e-18))*(z-0.47301805753666093)+-3.6844583421685405e-18))*(z-0.47301805753666093)+8.5966358822937731e-17);
  end
  else if (z < 1.8964605476229881) begin
    g = ((((((1.8525007249111924e-17)*(z-1.1847393025798247)+-2.0938006105749352e-18))*(z-1.1847393025798247)+-6.9133890707521686e-18))*(z-1.1847393025798247)+8.2165522042613139e-17);
  end
  else if (z < 2.6081817926661524) begin
    g = ((((((-8.2486291200640258e-17)*(z-1.8964605476229881)+3.7460123060739765e-17))*(z-1.8964605476229881)+1.8257573976077125e-17))*(z-1.8964605476229881)+8.2863149654774171e-17);
  end
  else if (z < 3.3199030377093166) begin
    g = ((((((-8.2486291200640258e-17)*(z-2.6081817926661524)+-1.3866161455619832e-16))*(z-2.6081817926661524)+-5.3769677551295834e-17))*(z-2.6081817926661524)+8.5094783841814419e-17);
  end
  else if (z < 4.0316242827524809) begin
    g = ((((((-8.2486291200640258e-17)*(z-3.3199030377093166)+-3.1478335217313642e-16))*(z-3.3199030377093166)+-3.7649609383045417e-16))*(z-3.3199030377093166)+-5.3150867939455369e-17);
  end
  else begin
    g = ((((((-8.2486291200640258e-17)*(z-4.0316242827524809)+-4.9090508979007447e-16))*(z-4.0316242827524809)+-9.4992167486139788e-16))*(z-4.0316242827524809)+-5.1030172735745719e-16);
  end
  y = y + g;
  z = (x5-40.036628336838596)/1.8014939372812893;
  z = min(max(z,-2.8923060494640653),2.483022719134016);
  if (z < -4.4281142690635171) begin
    g = ((((((-4.5957926259273228e-16)*(z--5.1960183788632435)+4.1027533363015188e-15))*(z--5.1960183788632435)+-1.0856865905469419e-14))*(z--5.1960183788632435)+1.8370489730751892e-15);
  end
  else if (z < -3.6602101592637912) begin
    g = ((((((-4.5957926259273228e-16)*(z--4.4281142690635171)+3.0440149227304585e-15))*(z--4.4281142690635171)+-5.3688331875725302e-15))*(z--4.4281142690635171)+-4.2887893030503699e-15);
  end
  else if (z < -2.8923060494640653) begin
    g = ((((((-4.5957926259273228e-16)*(z--3.6602101592637912)+1.9852765091593989e-15))*(z--3.6602101592637912)+-1.5068196276437576e-15))*(z--3.6602101592637912)+-6.8246580973959689e-15);
  end
  else if (z < -2.1244019396643394) begin
    g = ((((((-4.5957926259273228e-16)*(z--2.8923060494640653)+9.2653809558833938e-16))*(z--2.8923060494640653)+7.2917477431689547e-16))*(z--2.8923060494640653)+-7.0191842039783879e-15);
  end
  else if (z < -1.3564978298646138) begin
    g = ((((((6.9668075180648649e-17)*(z--2.1244019396643394)+-1.3220031798272026e-16))*(z--2.1244019396643394)+1.3391500183094311e-15))*(z--2.1244019396643394)+-6.1209944168144433e-15);
  end
  else if (z < -0.58859372006488808) begin
    g = ((((((-1.5553511798700409e-17)*(z--1.3564978298646138)+2.8294885776448809e-17))*(z--1.3564978298646138)+1.2593606098877186e-15))*(z--1.3564978298646138)+-5.1390643023765006e-15);
  end
  else if (z < 0.17931038973483782) begin
    g = ((((((2.9742429900619344e-17)*(z--0.58859372006488808)+-7.5359311196728944e-18))*(z--0.58859372006488808)+1.275301496483803e-15))*(z--0.58859372006488808)+-4.1623541450502713e-15);
  end
  else if (z < 0.94721449953456371) begin
    g = ((((((-6.4552539917435286e-17)*(z-0.17931038973483782)+6.0982071348674645e-17))*(z-0.17931038973483782)+1.3163430072185858e-15))*(z-0.17931038973483782)+-3.1740208241309807e-15);
  end
  else if (z < 1.7151186093342892) begin
    g = ((((((1.6464812766580135e-16)*(z-0.94721449953456371)+-8.7728410753153585e-17))*(z-0.94721449953456371)+1.2958043832677879e-15))*(z-0.94721449953456371)+-2.1564662809207324e-15);
  end
  else if (z < 2.483022719134016) begin
    g = ((((((-6.3394095599643361e-16)*(z-1.7151186093342892)+2.9157351096304256e-16))*(z-1.7151186093342892)+1.4523378734814986e-15))*(z-1.7151186093342892)+-1.1385889999160295e-15);
  end
  else if (z < 3.2509268289337427) begin
    g = ((((((-6.3394095599643361e-16)*(z-2.483022719134016)+-1.168844085477045e-15))*(z-2.483022719134016)+7.7867819390582862e-16))*(z-2.483022719134016)+-1.3845675286189971e-16);
  end
  else if (z < 4.0188309387334691) begin
    g = ((((((-6.3394095599643361e-16)*(z-3.2509268289337427)+-2.6292616819171325e-15))*(z-3.2509268289337427)+-2.1379028343302052e-15))*(z-3.2509268289337427)+-5.1680480315721379e-16);
  end
  else begin
    g = ((((((-6.3394095599643361e-16)*(z-4.0188309387334691)+-4.0896792783572184e-15))*(z-4.0188309387334691)+-7.2974052112265995e-15))*(z-4.0188309387334691)+-3.9959816723958072e-15);
  end
  y = y + g;
  z = (x6-299.53355240084676)/4.807585532709183;
  z = min(max(z,-2.9853167308618236),1.9419931515709017);
  if (z < -4.3931195544140307) begin
    g = ((((((-2.0316429250693325e-16)*(z--5.0970209661901347)+1.6758135191595153e-15))*(z--5.0970209661901347)+-4.4762985920985444e-15))*(z--5.0970209661901347)+3.3843926133819714e-15);
  end
  else if (z < -3.6892181426379271) begin
    g = ((((((-2.0316429250693325e-16)*(z--4.3931195544140307)+1.2467906222051441e-15))*(z--4.3931195544140307)+-2.4190734109292729e-15))*(z--4.3931195544140307)+9.9299007999669544e-16);
  end
  else if (z < -2.9853167308618236) begin
    g = ((((((-2.0316429250693325e-16)*(z--3.6892181426379271)+8.1776772525077335e-16))*(z--3.6892181426379271)+-9.6582787546091323e-16))*(z--3.6892181426379271)+-1.6289980666862899e-16);
  end
  else if (z < -2.28141531908572) begin
    g = ((((((-2.0316429250693325e-16)*(z--2.9853167308618236)+3.8874482829640261e-16))*(z--2.9853167308618236)+-1.1656198569346448e-16))*(z--2.9853167308618236)+-5.0841917190690769e-16);
  end
  else if (z < -1.5775139073096163) begin
    g = ((((((2.8116947587377749e-17)*(z--2.28141531908572)+-4.027806865796811e-17))*(z--2.28141531908572)+1.287242583730737e-16))*(z--2.28141531908572)+-4.6871014101104107e-16);
  end
  else if (z < -0.8736124955335125) begin
    g = ((((((-1.5776532674056837e-17)*(z--1.5775139073096163)+1.9096608646801631e-17))*(z--1.5775139073096163)+1.1381459876773451e-16))*(z--1.5775139073096163)+-3.8825155215396179e-16);
  end
  else if (z < -0.16971108375740895) begin
    g = ((((((1.3501545198977007e-17)*(z--0.8736124955335125)+-1.4218762219799676e-17))*(z--0.8736124955335125)+1.1724812175412822e-16))*(z--0.8736124955335125)+-3.0417769679676695e-16);
  end
  else if (z < 0.53419032801869459) begin
    g = ((((((-9.8610127535522018e-18)*(z--0.16971108375740895)+1.4292507960356685e-17))*(z--0.16971108375740895)+1.1730003148501877e-16))*(z--0.16971108375740895)+-2.2398275607385026e-16);
  end
  else if (z < 1.2380917397947986) begin
    g = ((((((1.4202779027681594e-17)*(z-0.53419032801869459)+-6.5310344359459839e-18))*(z-0.53419032801869459)+1.2276334365631432e-16))*(z-0.53419032801869459)+-1.3777268333023154e-16);
  end
  else if (z < 1.9419931515709017) begin
    g = ((((((-8.7252285017306297e-17)*(z-1.2380917397947986)+2.3461034190241357e-17))*(z-1.2380917397947986)+1.3468039438473191e-16))*(z-1.2380917397947986)+-4.9641909018583663e-17);
  end
  else if (z < 2.6458945633470048) begin
    g = ((((((-8.7252285017306297e-17)*(z-1.9419931515709017)+-1.6078998562287715e-16))*(z-1.9419931515709017)+3.8014351593567684e-17))*(z-1.9419931515709017)+2.6353491887235457e-17);
  end
  else if (z < 3.3497959751231079) begin
    g = ((((((-8.7252285017306297e-17)*(z-2.6458945633470048)+-3.4504100543599563e-16))*(z-2.6458945633470048)+-3.1804079713287833e-16))*(z-2.6458945633470048)+-5.6986650132048094e-17);
  end
  else begin
    g = ((((((-8.7252285017306297e-17)*(z-3.3497959751231079)+-5.2929202524911419e-16))*(z-3.3497959751231079)+-9.3348505179460592e-16))*(z-3.3497959751231079)+-4.8224669294362037e-16);
  end
  y = y + g;
  V(out) <+ y;
end
endmodule
