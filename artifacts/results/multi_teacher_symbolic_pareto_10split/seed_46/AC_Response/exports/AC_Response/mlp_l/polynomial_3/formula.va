`include "constants.vams"
`include "disciplines.vams"
module poly3_export(out);
output out; electrical out;
parameter real x0=0.0; // frequency_ghz
parameter real x1=0.0; // active_layer_length
parameter real x2=0.0; // simulation_temperature
real y;
analog begin
  y = -3.5471157560950006
    + (-3.7051340009989664)*(((x0-8.3277898747714616)/11.881455540915038))
    + (0.015428751329293854)*(((x1-39.989303855892182)/1.9524236265085084))
    + (0.035715489732510111)*(((x2-299.83227080551274)/4.6920728487850187))
    + (1.7573785507699256)*(((x0-8.3277898747714616)/11.881455540915038)*((x0-8.3277898747714616)/11.881455540915038))
    + (0.014248241635979935)*(((x0-8.3277898747714616)/11.881455540915038)*((x1-39.989303855892182)/1.9524236265085084))
    + (0.049909738404751061)*(((x0-8.3277898747714616)/11.881455540915038)*((x2-299.83227080551274)/4.6920728487850187))
    + (-0.0009146901548623094)*(((x1-39.989303855892182)/1.9524236265085084)*((x1-39.989303855892182)/1.9524236265085084))
    + (-0.00048747406852929785)*(((x1-39.989303855892182)/1.9524236265085084)*((x2-299.83227080551274)/4.6920728487850187))
    + (-0.0025279771099444171)*(((x2-299.83227080551274)/4.6920728487850187)*((x2-299.83227080551274)/4.6920728487850187))
    + (-0.31265524589808985)*(((x0-8.3277898747714616)/11.881455540915038)*((x0-8.3277898747714616)/11.881455540915038)*((x0-8.3277898747714616)/11.881455540915038))
    + (-0.0038001671752595128)*(((x0-8.3277898747714616)/11.881455540915038)*((x0-8.3277898747714616)/11.881455540915038)*((x1-39.989303855892182)/1.9524236265085084))
    + (-0.015350709993983755)*(((x0-8.3277898747714616)/11.881455540915038)*((x0-8.3277898747714616)/11.881455540915038)*((x2-299.83227080551274)/4.6920728487850187))
    + (0.00051276422652056324)*(((x0-8.3277898747714616)/11.881455540915038)*((x1-39.989303855892182)/1.9524236265085084)*((x1-39.989303855892182)/1.9524236265085084))
    + (0.00020911073887713803)*(((x0-8.3277898747714616)/11.881455540915038)*((x1-39.989303855892182)/1.9524236265085084)*((x2-299.83227080551274)/4.6920728487850187))
    + (0.00085798215296647518)*(((x0-8.3277898747714616)/11.881455540915038)*((x2-299.83227080551274)/4.6920728487850187)*((x2-299.83227080551274)/4.6920728487850187))
    + (-1.2743210392808486e-05)*(((x1-39.989303855892182)/1.9524236265085084)*((x1-39.989303855892182)/1.9524236265085084)*((x1-39.989303855892182)/1.9524236265085084))
    + (1.4172601345329369e-05)*(((x1-39.989303855892182)/1.9524236265085084)*((x1-39.989303855892182)/1.9524236265085084)*((x2-299.83227080551274)/4.6920728487850187))
    + (-0.00023123632557500205)*(((x1-39.989303855892182)/1.9524236265085084)*((x2-299.83227080551274)/4.6920728487850187)*((x2-299.83227080551274)/4.6920728487850187))
    + (-1.3949688405626095e-06)*(((x2-299.83227080551274)/4.6920728487850187)*((x2-299.83227080551274)/4.6920728487850187)*((x2-299.83227080551274)/4.6920728487850187))
  ;
  V(out) <+ y;
end
endmodule
