`include "constants.vams"
`include "disciplines.vams"
module poly3_export(out);
output out; electrical out;
parameter real x0=0.0; // bias_v
parameter real x1=0.0; // log_frequency_ghz
parameter real x2=0.0; // trap_assisted_recomb_A
parameter real x3=0.0; // ge_sio2_recomb_velocity
parameter real x4=0.0; // ge_si_recomb_velocity
parameter real x5=0.0; // active_layer_length
parameter real x6=0.0; // simulation_temperature
real y;
analog begin
  y = 2.7662094019697798e-14
    + (2.2183165708869435e-15)*(((x0--1.5)/0.92195444572928875))
    + (-4.3076025391279434e-16)*(((x1-0.19604119982655921)/0.71475520981330376))
    + (-3.3916816927865473e-18)*(((x2-1.0121035988307531e-09)/9.9180046100034365e-11))
    + (-1.9496324091702217e-18)*(((x3-2492.6527389352837)/93.523395336008221))
    + (-1.643422446278568e-18)*(((x4-499.65298500334421)/19.478443351568398))
    + (1.3836401559205361e-15)*(((x5-39.940393007693778)/1.9239540683366856))
    + (1.0310770402855156e-16)*(((x6-299.76390967124678)/4.7184642027229184))
    + (1.8764553457569205e-15)*(((x0--1.5)/0.92195444572928875)*((x0--1.5)/0.92195444572928875))
    + (-6.204768872992682e-17)*(((x0--1.5)/0.92195444572928875)*((x1-0.19604119982655921)/0.71475520981330376))
    + (-5.3264836957033333e-18)*(((x0--1.5)/0.92195444572928875)*((x2-1.0121035988307531e-09)/9.9180046100034365e-11))
    + (-1.8044310726109644e-18)*(((x0--1.5)/0.92195444572928875)*((x3-2492.6527389352837)/93.523395336008221))
    + (-2.6338659367853805e-18)*(((x0--1.5)/0.92195444572928875)*((x4-499.65298500334421)/19.478443351568398))
    + (1.1235973300460214e-16)*(((x0--1.5)/0.92195444572928875)*((x5-39.940393007693778)/1.9239540683366856))
    + (1.0538568994762099e-16)*(((x0--1.5)/0.92195444572928875)*((x6-299.76390967124678)/4.7184642027229184))
    + (-2.9646985963116152e-16)*(((x1-0.19604119982655921)/0.71475520981330376)*((x1-0.19604119982655921)/0.71475520981330376))
    + (-8.1482918002636327e-19)*(((x1-0.19604119982655921)/0.71475520981330376)*((x2-1.0121035988307531e-09)/9.9180046100034365e-11))
    + (2.6054849254393887e-20)*(((x1-0.19604119982655921)/0.71475520981330376)*((x3-2492.6527389352837)/93.523395336008221))
    + (-1.0908786192703957e-18)*(((x1-0.19604119982655921)/0.71475520981330376)*((x4-499.65298500334421)/19.478443351568398))
    + (1.4919874158213207e-17)*(((x1-0.19604119982655921)/0.71475520981330376)*((x5-39.940393007693778)/1.9239540683366856))
    + (1.3322823040850144e-17)*(((x1-0.19604119982655921)/0.71475520981330376)*((x6-299.76390967124678)/4.7184642027229184))
    + (9.0590451416951847e-19)*(((x2-1.0121035988307531e-09)/9.9180046100034365e-11)*((x2-1.0121035988307531e-09)/9.9180046100034365e-11))
    + (4.9389732900688362e-19)*(((x2-1.0121035988307531e-09)/9.9180046100034365e-11)*((x3-2492.6527389352837)/93.523395336008221))
    + (1.9530220383980814e-19)*(((x2-1.0121035988307531e-09)/9.9180046100034365e-11)*((x4-499.65298500334421)/19.478443351568398))
    + (-3.8610737052610814e-18)*(((x2-1.0121035988307531e-09)/9.9180046100034365e-11)*((x5-39.940393007693778)/1.9239540683366856))
    + (-8.4305530745083118e-19)*(((x2-1.0121035988307531e-09)/9.9180046100034365e-11)*((x6-299.76390967124678)/4.7184642027229184))
    + (-7.6399416193635761e-19)*(((x3-2492.6527389352837)/93.523395336008221)*((x3-2492.6527389352837)/93.523395336008221))
    + (-1.1415989166226781e-18)*(((x3-2492.6527389352837)/93.523395336008221)*((x4-499.65298500334421)/19.478443351568398))
    + (-3.1756653762096043e-18)*(((x3-2492.6527389352837)/93.523395336008221)*((x5-39.940393007693778)/1.9239540683366856))
    + (-1.4420192464676126e-18)*(((x3-2492.6527389352837)/93.523395336008221)*((x6-299.76390967124678)/4.7184642027229184))
    + (-9.7120181735524749e-19)*(((x4-499.65298500334421)/19.478443351568398)*((x4-499.65298500334421)/19.478443351568398))
    + (-5.2595426319787506e-20)*(((x4-499.65298500334421)/19.478443351568398)*((x5-39.940393007693778)/1.9239540683366856))
    + (4.7716279597675772e-19)*(((x4-499.65298500334421)/19.478443351568398)*((x6-299.76390967124678)/4.7184642027229184))
    + (1.3288854020993203e-17)*(((x5-39.940393007693778)/1.9239540683366856)*((x5-39.940393007693778)/1.9239540683366856))
    + (5.8334404442489915e-18)*(((x5-39.940393007693778)/1.9239540683366856)*((x6-299.76390967124678)/4.7184642027229184))
    + (4.3475379830723616e-18)*(((x6-299.76390967124678)/4.7184642027229184)*((x6-299.76390967124678)/4.7184642027229184))
  ;
  V(out) <+ y;
end
endmodule
