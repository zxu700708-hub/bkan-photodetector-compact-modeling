`include "constants.vams"
`include "disciplines.vams"
module spline_ridge_export(out);
output out; electrical out;
parameter real x0=0.0; // frequency_ghz
parameter real x1=0.0; // active_layer_length
parameter real x2=0.0; // simulation_temperature
real y,z,g;
analog begin
  y = -6.9989299147085378;
  z = (x0-8.3277898747714616)/11.881455540915038;
  z = min(max(z,-0.69249006120825896),2.6656843529113048);
  if (z < -1.65196846524242) begin
    g = ((((((0.16386909908479907)*(z--2.1317076672595006)+1.1587549173181841))*(z--2.1317076672595006)+-10.807679098014612))*(z--2.1317076672595006)+19.693252815272515);
  end
  else if (z < -1.1722292632253395) begin
    g = ((((((0.16386909908479907)*(z--1.65196846524242)+1.3945982098087821))*(z--1.65196846524242)+-9.5827355063388993))*(z--1.65196846524242)+14.793165655815175);
  end
  else if (z < -0.69249006120825896) begin
    g = ((((((0.16386909908479907)*(z--1.1722292632253395)+1.6304415022993806))*(z--1.1722292632253395)+-8.1315053687821539))*(z--1.1722292632253395)+10.535011221018374);
  end
  else if (z < -0.21275085919117848) begin
    g = ((((((0.16386909908479907)*(z--0.69249006120825896)+1.8662847947899786))*(z--0.69249006120825896)+-6.4539886853443598))*(z--0.69249006120825896)+7.0273480378302606);
  end
  else if (z < 0.266988342825902) begin
    g = ((((((-0.33151925628015183)*(z--0.21275085919117848)+2.1021280872805765))*(z--0.21275085919117848)+-4.5501854560255302))*(z--0.21275085919117848)+4.3787346331990227);
  end
  else if (z < 0.74672754484298243) begin
    g = ((((((-0.49515944040908733)*(z-0.266988342825902)+1.6249997368971689))*(z-0.266988342825902)+-2.7621361278388421))*(z-0.266988342825902)+2.6430327970369358);
  end
  else if (z < 1.226466746860063) begin
    g = ((((((-0.33595337323631985)*(z-0.74672754484298243)+0.91235755245793004))*(z-0.74672754484298243)+-1.5448663666114042))*(z-0.74672754484298243)+1.637249558208218);
  end
  else if (z < 1.7062059488771435) begin
    g = ((((((-0.17994284751297548)*(z-1.226466746860063)+0.42884754288391452))*(z-1.226466746860063)+-0.90143770443086557))*(z-1.226466746860063)+1.0690021908407845);
  end
  else if (z < 2.1859451508942236) begin
    g = ((((((-0.074213264741771076)*(z-1.7062059488771435)+0.16987062866024635))*(z-1.7062059488771435)+-0.61420912658114424))*(z-1.7062059488771435)+0.71537850015291227);
  end
  else if (z < 2.6656843529113048) begin
    g = ((((((-0.034318003608712747)*(z-2.1859451508942236)+0.063061591441347667))*(z-2.1859451508942236)+-0.50246240918553864))*(z-2.1859451508942236)+0.45161995575791564);
  end
  else if (z < 3.145423554928386) begin
    g = ((((((-0.034318003608712747)*(z-2.6656843529113048)+0.013670516443158179))*(z-2.6656843529113048)+-0.46565100897993728))*(z-2.6656843529113048)+0.22129353327653545);
  end
  else if (z < 3.6251627569454672) begin
    g = ((((((-0.034318003608712747)*(z-3.145423554928386)+-0.035720558555031312))*(z-3.145423554928386)+-0.47622927858713032))*(z-3.145423554928386)+-0.0027403586349996345);
  end
  else begin
    g = ((((((-0.034318003608712747)*(z-3.6251627569454672)+-0.085111633553220795))*(z-3.6251627569454672)+-0.53419721800711772))*(z-3.6251627569454672)+-0.24321640235653308);
  end
  y = y + g;
  z = (x1-40.032487245505138)/1.967894180694129;
  z = min(max(z,-2.6381674696102713),2.4364288843468751);
  if (z < -4.0880521421694551) begin
    g = ((((((-0.0036389615982732014)*(z--4.8129944784490473)+0.030413332522599468))*(z--4.8129944784490473)+-0.081233103090089201))*(z--4.8129944784490473)+0.058289722169651621);
  end
  else if (z < -3.3631098058898634) begin
    g = ((((((-0.0036389615982732014)*(z--4.0880521421694551)+0.022499220554547786))*(z--4.0880521421694551)+-0.042874553243824151))*(z--4.0880521421694551)+0.01399747390515056);
  end
  else if (z < -2.6381674696102713) begin
    g = ((((((-0.0036389615982732014)*(z--3.3631098058898634)+0.014585108586496111))*(z--3.3631098058898634)+-0.015990553036954444))*(z--3.3631098058898634)+-0.0066462310291715591);
  end
  else if (z < -1.9132251333306791) begin
    g = ((((((-0.0036389615982732014)*(z--2.6381674696102713)+0.0066709966184444322))*(z--2.6381674696102713)+-0.0005811024694800499))*(z--2.6381674696102713)+-0.011959779456654206);
  end
  else if (z < -1.1882827970510867) begin
    g = ((((((0.00039582702479644204)*(z--1.9132251333306791)+-0.001243115349607248))*(z--1.9132251333306791)+0.0033537984585990149))*(z--1.9132251333306791)+-0.010261558200636777);
  end
  else if (z < -0.46334046077149438) begin
    g = ((((((0.00025836701315918052)*(z--1.1882827970510867)+-0.00038226004525164953))*(z--1.1882827970510867)+0.002175495022518641))*(z--1.1882827970510867)+-0.0083327512492217919);
  end
  else if (z < 0.26160187550809777) begin
    g = ((((((-8.873411316275466e-05)*(z--0.46334046077149438)+0.00017964351315994002))*(z--0.46334046077149438)+0.0020286097203752081))*(z--0.46334046077149438)+-0.00685810175502574);
  end
  else if (z < 0.98654421178768992) begin
    g = ((((((-0.00010430689934037871)*(z-0.26160187550809777)+-1.3337832751775223e-05))*(z-0.26160187550809777)+0.0021491717488668701))*(z-0.26160187550809777)+-0.0053268731448110895);
  end
  else if (z < 1.7114865480672825) begin
    g = ((((((0.00038952606959656843)*(z-0.98654421178768992)+-0.00024018729464545842))*(z-0.98654421178768992)+0.001965380650705938))*(z-0.98654421178768992)+-0.0038155967332096246);
  end
  else if (z < 2.4364288843468751) begin
    g = ((((((-0.00089069793367053788)*(z-1.7114865480672825)+0.00060696452215997204))*(z-1.7114865480672825)+0.0022312729909144615))*(z-1.7114865480672825)+-0.0023686330094755547);
  end
  else if (z < 3.1613712206264677) begin
    g = ((((((-0.00089069793367053788)*(z-2.4364288843468751)+-0.0013301494007036043))*(z-2.4364288843468751)+0.0017070056555009672))*(z-2.4364288843468751)+-0.00077144829048057394);
  end
  else if (z < 3.8863135569060603) begin
    g = ((((((-0.00089069793367053788)*(z-3.1613712206264677)+-0.0032672633235671807))*(z-3.1613712206264677)+-0.0016258534656734228))*(z-3.1613712206264677)+-0.0005723607038679167);
  end
  else begin
    g = ((((((-0.00089069793367053788)*(z-3.8863135569060603)+-0.0052043772464307574))*(z-3.8863135569060603)+-0.0077673043726087078))*(z-3.8863135569060603)+-0.0038074373404627581);
  end
  y = y + g;
  z = (x2-299.55241399998533)/4.4484154535657945;
  z = min(max(z,-2.57862968859641),2.1732365992259028);
  if (z < -3.9363057708313565) begin
    g = ((((((0.0037077808151647993)*(z--4.6151438119488297)+-0.030300607829891933))*(z--4.6151438119488297)+0.10349444385374461))*(z--4.6151438119488297)+-0.23454093138119192);
  end
  else if (z < -3.2574677297138832) begin
    g = ((((((0.0037077808151647993)*(z--3.9363057708313565)+-0.022749659833513673))*(z--3.9363057708313565)+0.06748190407236071))*(z--3.9363057708313565)+-0.17708824617215949);
  end
  else if (z < -2.57862968859641) begin
    g = ((((((0.0037077808151647993)*(z--3.2574677297138832)+-0.01519871183713541))*(z--3.2574677297138832)+0.041721105783859486))*(z--3.2574677297138832)+-0.14060260686745096);
  end
  else if (z < -1.8997916474789367) begin
    g = ((((((0.0037077808151647993)*(z--2.57862968859641)+-0.0076477638407571481))*(z--2.57862968859641)+0.026212048988240907))*(z--2.57862968859641)+-0.11812474135399552);
  end
  else if (z < -1.2209536063614632) begin
    g = ((((((-0.00088612344452414411)*(z--1.8997916474789367)+-9.6815844378886636e-05))*(z--1.8997916474789367)+0.020954733685504982))*(z--1.8997916474789367)+-0.10269537751872183);
  end
  else if (z < -0.54211556524398974) begin
    g = ((((((0.0011111420879449656)*(z--1.2209536063614632)+-0.001901418754186001))*(z--1.2209536063614632)+0.019598256024922031))*(z--1.2209536063614632)+-0.088792321625010287);
  end
  else if (z < 0.13672247587348352) begin
    g = ((((((0.00027530431564047755)*(z--0.54211556524398974)+0.00036143780096521856))*(z--0.54211556524398974)+0.018552858371279415))*(z--0.54211556524398974)+-0.076016903079320852);
  end
  else if (z < 0.81556051699095677) begin
    g = ((((((0.00045142702305120603)*(z-0.13672247587348352)+0.00092209892798692363))*(z-0.13672247587348352)+0.01942417193006362))*(z-0.13672247587348352)+-0.063169837395621264);
  end
  else if (z < 1.4943985581084305) begin
    g = ((((((0.00050004426277660771)*(z-0.81556051699095677)+0.0018414364360936431))*(z-0.81556051699095677)+0.021300164863174931))*(z-0.81556051699095677)+-0.049417831239847609);
  end
  else if (z < 2.1732365992259028) begin
    g = ((((((-0.0022005037595750148)*(z-1.4943985581084305)+0.002859783639539554))*(z-1.4943985581084305)+0.024491531890179916))*(z-1.4943985581084305)+-0.033953471022148962);
  end
  else if (z < 2.8520746403433752) begin
    g = ((((((-0.0022005037595750148)*(z-2.1732365992259028)+-0.0016215733453250553))*(z-2.1732365992259028)+0.025332076140795974))*(z-2.1732365992259028)+-0.016698206818101968);
  end
  else if (z < 3.5309126814608476) begin
    g = ((((((-0.0022005037595750148)*(z-2.8520746403433752)+-0.006102930330189665))*(z-2.8520746403433752)+0.020088389197104844))*(z-2.8520746403433752)+-0.00093745299431886343);
  end
  else begin
    g = ((((((-0.0022005037595750148)*(z-3.5309126814608476)+-0.010584287315054274))*(z-3.5309126814608476)+0.0087604710591065171))*(z-3.5309126814608476)+0.0091985828635510331);
  end
  y = y + g;
  V(out) <+ y;
end
endmodule
