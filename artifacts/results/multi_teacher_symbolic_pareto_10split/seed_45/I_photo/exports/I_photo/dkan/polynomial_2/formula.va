`include "constants.vams"
`include "disciplines.vams"
module poly3_export(out);
output out; electrical out;
parameter real x0=0.0; // light_voltage
parameter real x1=0.0; // trap_assisted_recomb_A
parameter real x2=0.0; // ge_sio2_recomb_velocity
parameter real x3=0.0; // ge_si_recomb_velocity
parameter real x4=0.0; // active_layer_length
parameter real x5=0.0; // simulation_temperature
real y;
analog begin
  y = -3.297345528913795
    + (-0.020758238518788771)*(((x0--1.5000000000000002)/0.92195444572928875))
    + (0.00080014268607159146)*(((x1-1.0106427937642328e-09)/9.5532139207119233e-11))
    + (-0.0013836547944301122)*(((x2-2504.0234043224455)/93.807986847671742))
    + (-0.00012280936943327006)*(((x3-499.73068053516067)/17.932090153704081))
    + (0.0043401848340631627)*(((x4-39.934895127721752)/1.9112273535135149))
    + (-0.0016798707688615944)*(((x5-299.17555737907139)/4.9223461599347278))
    + (-0.0066194629851145815)*(((x0--1.5000000000000002)/0.92195444572928875)*((x0--1.5000000000000002)/0.92195444572928875))
    + (0.00020926777219909572)*(((x0--1.5000000000000002)/0.92195444572928875)*((x1-1.0106427937642328e-09)/9.5532139207119233e-11))
    + (-0.00015850769636174033)*(((x0--1.5000000000000002)/0.92195444572928875)*((x2-2504.0234043224455)/93.807986847671742))
    + (5.5082808653401645e-05)*(((x0--1.5000000000000002)/0.92195444572928875)*((x3-499.73068053516067)/17.932090153704081))
    + (-4.4643380968016952e-05)*(((x0--1.5000000000000002)/0.92195444572928875)*((x4-39.934895127721752)/1.9112273535135149))
    + (-0.00021819643944474132)*(((x0--1.5000000000000002)/0.92195444572928875)*((x5-299.17555737907139)/4.9223461599347278))
    + (-0.00086528036667988498)*(((x1-1.0106427937642328e-09)/9.5532139207119233e-11)*((x1-1.0106427937642328e-09)/9.5532139207119233e-11))
    + (5.5491803641918706e-05)*(((x1-1.0106427937642328e-09)/9.5532139207119233e-11)*((x2-2504.0234043224455)/93.807986847671742))
    + (-0.00030167755407144793)*(((x1-1.0106427937642328e-09)/9.5532139207119233e-11)*((x3-499.73068053516067)/17.932090153704081))
    + (0.00020021302409950007)*(((x1-1.0106427937642328e-09)/9.5532139207119233e-11)*((x4-39.934895127721752)/1.9112273535135149))
    + (0.00052013208596660555)*(((x1-1.0106427937642328e-09)/9.5532139207119233e-11)*((x5-299.17555737907139)/4.9223461599347278))
    + (0.00021481128973447602)*(((x2-2504.0234043224455)/93.807986847671742)*((x2-2504.0234043224455)/93.807986847671742))
    + (-3.1685489820294601e-05)*(((x2-2504.0234043224455)/93.807986847671742)*((x3-499.73068053516067)/17.932090153704081))
    + (-0.00049644437697344711)*(((x2-2504.0234043224455)/93.807986847671742)*((x4-39.934895127721752)/1.9112273535135149))
    + (0.00015143674985220528)*(((x2-2504.0234043224455)/93.807986847671742)*((x5-299.17555737907139)/4.9223461599347278))
    + (-3.8155760860229601e-05)*(((x3-499.73068053516067)/17.932090153704081)*((x3-499.73068053516067)/17.932090153704081))
    + (0.00081072566315117318)*(((x3-499.73068053516067)/17.932090153704081)*((x4-39.934895127721752)/1.9112273535135149))
    + (-0.00024223437331182722)*(((x3-499.73068053516067)/17.932090153704081)*((x5-299.17555737907139)/4.9223461599347278))
    + (0.00020130111490547506)*(((x4-39.934895127721752)/1.9112273535135149)*((x4-39.934895127721752)/1.9112273535135149))
    + (-0.00011851366068884171)*(((x4-39.934895127721752)/1.9112273535135149)*((x5-299.17555737907139)/4.9223461599347278))
    + (-5.0024138921623826e-05)*(((x5-299.17555737907139)/4.9223461599347278)*((x5-299.17555737907139)/4.9223461599347278))
  ;
  V(out) <+ y;
end
endmodule
