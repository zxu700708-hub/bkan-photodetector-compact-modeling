simulator lang=spectre
ahdl_include "ge_si_photodetector_terminal_charge.va"

Vbias (bias 0) vsource dc=1.0
Iinj (in 0) isource type=pulse val0=0 val1=20u delay=1n rise=100p fall=100p width=2n period=5n
Xpd (in bias) ge_si_photodetector_terminal_charge active_layer_length=40.0 sim_temp=300.0 trap_assisted_recomb_A=1.0e-9 ge_sio2_recomb_velocity=2500.0 ge_si_recomb_velocity=500.0 area=1.0 light_power=1.0
Gm (out 0 in 0) vccs gm=0.1
Rout (out 0) resistor r=1Meg
Cdom (out 0) capacitor c=1p
Rf (out in) resistor r=2k
Cf (out in) capacitor c=50f
Cload (out 0) capacitor c=100f

save in out Iinj:p Vbias:p
tia_transient tran stop=10n maxstep=2p
