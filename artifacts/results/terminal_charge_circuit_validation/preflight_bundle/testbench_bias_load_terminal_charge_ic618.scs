simulator lang=spectre
ahdl_include "ge_si_photodetector_terminal_charge.va"

parameters Vsweep=-2.4
Vdrive (supply 0) vsource dc=Vsweep
Rbias (supply pd) resistor r=1k
Xpd (pd 0) ge_si_photodetector_terminal_charge active_layer_length=40.0 sim_temp=300.0 trap_assisted_recomb_A=1.0e-9 ge_sio2_recomb_velocity=2500.0 ge_si_recomb_velocity=500.0 area=1.0 light_power=1.0

save Vdrive:p supply pd
bias_load dc param=Vsweep start=-2.4 stop=0.4 step=0.05
