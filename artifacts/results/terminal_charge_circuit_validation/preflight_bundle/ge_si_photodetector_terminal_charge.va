// Locally audited terminal-charge dynamic model for Ge/Si photodetector
// Generated by bkan/device_modeling/terminal_charge/train.py
//
// Qp is fitted to production terminal Q-V values and independently constrained
// by strict two-contact SSAC dQ/dV evidence; Qn = -Qp on this branch.

`include "disciplines.vams"
`include "constants.vams"

module ge_si_photodetector_terminal_charge(anode, cathode);

  inout anode, cathode;
  electrical anode, cathode;

  parameter real active_layer_length = 40.0 from (0.1:100.0);
  parameter real trap_assisted_recomb_A = 1.0e-9 from [0:1.0e-5];
  parameter real ge_sio2_recomb_velocity = 2500.0 from [1.0:1.0e6];
  parameter real ge_si_recomb_velocity = 500.0 from [1.0:1.0e6];
  parameter real sim_temp = 300.0;
  parameter real area = 1.0;
  parameter real light_power = 0.0;
  parameter real v_min = -3.0;
  parameter real v_max = 0.0;
  parameter real smooth_delta = 1.0e-18;
  parameter real sqrt_eps = 1.0e-30;

  real vd, vd_safe, T;
  real dark_current, photo_current, dc_current;
  real q_terminal;

  analog function real smax0;
    input x, delta;
    real x, delta;
    begin
      smax0 = 0.5 * (x + sqrt(x*x + 4.0*delta*delta));
    end
  endfunction

  analog function real sqr;
    input x;
    real x;
    begin
      sqr = x*x;
    end
  endfunction

  analog function real safe_exp_kan;
    input x;
    real x;
    begin
      if (x < -80.0)
        safe_exp_kan = exp(-80.0);
      else if (x < 80.0)
        safe_exp_kan = exp(x);
      else
        safe_exp_kan = exp(80.0) * (1.0 + x - 80.0);
    end
  endfunction

  analog function real safe_sqrt_kan;
    input x, eps, delta;
    real x, eps, delta;
    begin
      safe_sqrt_kan = sqrt(smax0(x, delta) + eps);
    end
  endfunction

  analog function real dark_boundary_gate;
    input v;
    real v, u;
    begin
      if (v <= -2.00000000000000011e-01)
        dark_boundary_gate = 1.0;
      else if (v >= 0.00000000000000000e+00)
        dark_boundary_gate = 0.0;
      else begin
        u = (v - -2.00000000000000011e-01) /
            (0.00000000000000000e+00 - -2.00000000000000011e-01);
        dark_boundary_gate = 1.0 - u*u*(3.0 - 2.0*u);
      end
    end
  endfunction

  analog function real terminal_charge_model;
    input vd_raw, trap_assisted_recomb_A, ge_sio2_recomb_velocity, ge_si_recomb_velocity, active_layer_length, sim_temp;
    real vd_raw, trap_assisted_recomb_A, ge_sio2_recomb_velocity, ge_si_recomb_velocity, active_layer_length, sim_temp;
    real z0, z1, z2, z3, z4;
    real p0, p1, p2, p3, p4, p5;
    real b0, b1, b2, b3, b4, b5, b6, b7, b8, b9, b10, b11, b12, b13;
    real t0, t1, t2, t3, t4, t5, t6, t7, t8, t9, t10;
    real acc;
    begin
      z0 = (trap_assisted_recomb_A - 1.00205806046816974e-09) / 9.56723580081005492e-11;
      z1 = (ge_sio2_recomb_velocity - 2.50344038426073348e+03) / 9.80430525826589871e+01;
      z2 = (ge_si_recomb_velocity - 4.99449941712577072e+02) / 1.82749426344617198e+01;
      z3 = (active_layer_length - 3.99586403701080144e+01) / 1.90790201333369347e+00;
      z4 = (sim_temp - 2.99592878274857867e+02) / 4.75220788418486606e+00;
      p0 = 1.0;
      p1 = z0;
      p2 = z1;
      p3 = z2;
      p4 = z3;
      p5 = z4;
      b0 = vd_raw;
      b1 = vd_raw * vd_raw;
      b2 = b1 * vd_raw;
      if (vd_raw > -2.75000000000000000e+00)
        t0 = vd_raw - -2.75000000000000000e+00;
      else
        t0 = 0.0;
      b3 = t0 * t0 * t0 - 2.07968750000000000e+01;
      if (vd_raw > -2.50000000000000000e+00)
        t1 = vd_raw - -2.50000000000000000e+00;
      else
        t1 = 0.0;
      b4 = t1 * t1 * t1 - 1.56250000000000000e+01;
      if (vd_raw > -2.25000000000000000e+00)
        t2 = vd_raw - -2.25000000000000000e+00;
      else
        t2 = 0.0;
      b5 = t2 * t2 * t2 - 1.13906250000000000e+01;
      if (vd_raw > -2.00000000000000000e+00)
        t3 = vd_raw - -2.00000000000000000e+00;
      else
        t3 = 0.0;
      b6 = t3 * t3 * t3 - 8.00000000000000000e+00;
      if (vd_raw > -1.75000000000000000e+00)
        t4 = vd_raw - -1.75000000000000000e+00;
      else
        t4 = 0.0;
      b7 = t4 * t4 * t4 - 5.35937500000000000e+00;
      if (vd_raw > -1.50000000000000000e+00)
        t5 = vd_raw - -1.50000000000000000e+00;
      else
        t5 = 0.0;
      b8 = t5 * t5 * t5 - 3.37500000000000000e+00;
      if (vd_raw > -1.25000000000000000e+00)
        t6 = vd_raw - -1.25000000000000000e+00;
      else
        t6 = 0.0;
      b9 = t6 * t6 * t6 - 1.95312500000000000e+00;
      if (vd_raw > -1.00000000000000000e+00)
        t7 = vd_raw - -1.00000000000000000e+00;
      else
        t7 = 0.0;
      b10 = t7 * t7 * t7 - 1.00000000000000000e+00;
      if (vd_raw > -7.50000000000000000e-01)
        t8 = vd_raw - -7.50000000000000000e-01;
      else
        t8 = 0.0;
      b11 = t8 * t8 * t8 - 4.21875000000000000e-01;
      if (vd_raw > -5.00000000000000000e-01)
        t9 = vd_raw - -5.00000000000000000e-01;
      else
        t9 = 0.0;
      b12 = t9 * t9 * t9 - 1.25000000000000000e-01;
      if (vd_raw > -2.50000000000000000e-01)
        t10 = vd_raw - -2.50000000000000000e-01;
      else
        t10 = 0.0;
      b13 = t10 * t10 * t10 - 1.56250000000000000e-02;
      acc = 0.0;
      acc = acc + 3.47837548875503277e-01 * b0 * p0;
      acc = acc + 2.35757030117430752e-04 * b0 * p1;
      acc = acc + 3.74914455015297639e-03 * b0 * p2;
      acc = acc + -1.80908329199027480e-03 * b0 * p3;
      acc = acc + 1.79802936251954280e-02 * b0 * p4;
      acc = acc + -2.59321554475388117e-03 * b0 * p5;
      acc = acc + 2.39429580570516498e-01 * b1 * p0;
      acc = acc + -1.31403670111918461e-03 * b1 * p1;
      acc = acc + 2.94667296621857738e-03 * b1 * p2;
      acc = acc + -1.06910467236169364e-03 * b1 * p3;
      acc = acc + 1.30357931092134616e-02 * b1 * p4;
      acc = acc + -3.71958259681445195e-03 * b1 * p5;
      acc = acc + 6.32075569178941893e-02 * b2 * p0;
      acc = acc + -3.24350716335038321e-04 * b2 * p1;
      acc = acc + 5.36396503265021418e-04 * b2 * p2;
      acc = acc + -1.75033166830221298e-04 * b2 * p3;
      acc = acc + 3.34548936169708905e-03 * b2 * p4;
      acc = acc + -6.55618736616155398e-04 * b2 * p5;
      acc = acc + 4.76901354092697627e-01 * b3 * p0;
      acc = acc + -2.99748684915569774e-03 * b3 * p1;
      acc = acc + 3.50071551284725224e-03 * b3 * p2;
      acc = acc + -9.69995886940494545e-04 * b3 * p3;
      acc = acc + 2.51707904021284748e-02 * b3 * p4;
      acc = acc + -4.55265091505610911e-03 * b3 * p5;
      acc = acc + -8.28816864349560256e-01 * b4 * p0;
      acc = acc + 4.96760268735293130e-03 * b4 * p1;
      acc = acc + -6.34941891697128613e-03 * b4 * p2;
      acc = acc + 1.93277702062302770e-03 * b4 * p3;
      acc = acc + -4.38122733073785658e-02 * b4 * p4;
      acc = acc + 8.06633325575558009e-03 * b4 * p5;
      acc = acc + 1.86565281498269564e-01 * b5 * p0;
      acc = acc + -2.80985504263878139e-04 * b5 * p1;
      acc = acc + 1.03954097707588053e-03 * b5 * p2;
      acc = acc + -7.43367287536988997e-04 * b5 * p3;
      acc = acc + 9.89068039442808633e-03 * b5 * p4;
      acc = acc + -2.11729056356634027e-03 * b5 * p5;
      acc = acc + 4.72288209541262216e-01 * b6 * p0;
      acc = acc + -4.93943492550352747e-03 * b6 * p1;
      acc = acc + 5.03402051410184459e-03 * b6 * p2;
      acc = acc + -6.34568839838214882e-04 * b6 * p3;
      acc = acc + 2.48083884948167716e-02 * b6 * p4;
      acc = acc + -3.71516680424258117e-03 * b6 * p5;
      acc = acc + -5.86724921590711435e-01 * b7 * p0;
      acc = acc + 5.55108948181526340e-03 * b7 * p1;
      acc = acc + -6.03808083690210440e-03 * b7 * p2;
      acc = acc + 9.51372509593761961e-04 * b7 * p3;
      acc = acc + -3.07418554422633494e-02 * b7 * p4;
      acc = acc + 4.67427076748033743e-03 * b7 * p5;
      acc = acc + 2.21402242455231713e-02 * b8 * p0;
      acc = acc + -8.03783476865937985e-06 * b8 * p1;
      acc = acc + 1.85805632407082255e-04 * b8 * p2;
      acc = acc + 1.86917894156937714e-05 * b8 * p3;
      acc = acc + 1.15091290633026477e-03 * b8 * p4;
      acc = acc + -9.52878905723375524e-05 * b8 * p5;
      acc = acc + 5.50934910871198724e-01 * b9 * p0;
      acc = acc + -4.92860972368205918e-03 * b9 * p1;
      acc = acc + 5.96062983046037609e-03 * b9 * p2;
      acc = acc + -9.73635424314826803e-04 * b9 * p3;
      acc = acc + 2.88266758440814674e-02 * b9 * p4;
      acc = acc + -4.32520144625447855e-03 * b9 * p5;
      acc = acc + -5.37029229903203786e-01 * b10 * p0;
      acc = acc + 4.10945575927379458e-03 * b10 * p1;
      acc = acc + -6.06797063484662558e-03 * b10 * p2;
      acc = acc + 1.06326312898733649e-03 * b10 * p3;
      acc = acc + -2.79807689904196799e-02 * b10 * p4;
      acc = acc + 3.87650151379145824e-03 * b10 * p5;
      acc = acc + 2.11007458151704907e-01 * b11 * p0;
      acc = acc + -1.02038652180697076e-03 * b11 * p1;
      acc = acc + 2.67286675422780118e-03 * b11 * p2;
      acc = acc + -7.19561019334909180e-04 * b11 * p3;
      acc = acc + 1.07494031877599788e-02 * b11 * p4;
      acc = acc + -1.16067878501176225e-03 * b11 * p5;
      acc = acc + -6.87356537899049685e-03 * b12 * p0;
      acc = acc + -2.89635254597714331e-04 * b12 * p1;
      acc = acc + -5.27675620872712636e-04 * b12 * p2;
      acc = acc + 2.72503429442991912e-04 * b12 * p3;
      acc = acc + -1.94620175968170106e-04 * b12 * p4;
      acc = acc + -3.27295756128449800e-04 * b12 * p5;
      acc = acc + -1.31473984383959436e-01 * b13 * p0;
      acc = acc + -7.34064059127237378e-04 * b13 * p1;
      acc = acc + 5.71591714608330609e-04 * b13 * p2;
      acc = acc + -1.11053399566896777e-04 * b13 * p3;
      acc = acc + -6.00828401727432349e-03 * b13 * p4;
      acc = acc + -3.88550559082372939e-03 * b13 * p5;
      terminal_charge_model = 2.51113537013889362e-15 * acc;
    end
  endfunction
analog begin
    vd = V(anode, cathode);
    T = sim_temp;

    if (vd < v_min)
      vd_safe = v_min;
    else if (vd > v_max)
      vd_safe = v_max;
    else
      vd_safe = vd;

    // DC source: symbolic KAN formulas from artifacts/results/device_modeling/I-dark-bayes-results/symbolic_formula.txt and artifacts/results/device_modeling/I-photo-bayes-results/symbolic_formula.txt.
    dark_current = dark_boundary_gate(vd_safe) * smax0(pow(10, 0.0041364920460940603*T - 8979627246308360.0*sqr(6.6960677352389096e-10 - safe_exp_kan(-0.068282438309411303*T)) + 4.1655510196711703*sqr(-0.0037685927983991002*T + 1 + 0.35055107291988502/(2.7419450672245702 - 3.99278414053469*vd_safe)) + 11.091804671452*sqr(-0.0036384309408752299*T + 1 + 0.27795067599470802/(2.71809355668523 - 3.91344149021847*vd_safe)) - 4.0797652084980403*sqr(0.0031437998134108301*T - 1 - 0.129413223340552/(1.9810310906033299 - 4.2284055530582396*vd_safe)) - 10.890950950498899*sqr(0.0032060372831007001*T - 1 - 0.067104895549517998/(1.0388148580098799 - 1.47159079721493*vd_safe)) - 7.12316065714458*sqr(0.0032401308694073399*T - 1 - 0.152897530929964/(1.65810271741587 - 4.9512858805121001*vd_safe)) - 7.9153253720267003*sqr(0.0031007692729312099*T + 0.43802923045546699*sqr(1 - 0.027698242091027201*active_layer_length) - 1 - 0.25256010136551499/(2.3734751394050502 - 2.5912779117378402*vd_safe)) - 7.6048937528310399 - 0.146112698632896/(1.21672301165792 - 1.4259479623268201*vd_safe)), smooth_delta);
    photo_current = smax0(pow(10, -0.014504251095571101*sqr(-0.304660746275493*vd_safe - 1) - 0.00879972112992739*sqr(0.34506128024025401*safe_sqrt_kan(0.0020061858936205202 - vd_safe, sqrt_eps, smooth_delta) + 0.0030861531873339898*safe_exp_kan(4269713641.0529399*trap_assisted_recomb_A) - 1) - 0.019662584876536899*sqr(0.49258729322719003*safe_sqrt_kan(0.11724480586293801 - vd_safe, sqrt_eps, smooth_delta) + 1.0868170263734301e-8*safe_exp_kan(0.031558430517720698*ge_si_recomb_velocity) - 1.1854731994142201e-5*safe_exp_kan(0.0038523925984506702*ge_sio2_recomb_velocity) - 1) - 0.028207595180121*sqr(0.326758643287686*safe_sqrt_kan(0.14782816836177101 - vd_safe, sqrt_eps, smooth_delta) - 1 - 0.157032375818627*safe_exp_kan(-57.215375755633303*sqr(1 - 0.026808991153413699*active_layer_length)) - 0.78291642437031195*safe_exp_kan(-120.76644898671699*sqr(1 - 0.00278725855957155*T))) + 0.013746151162503301*sqr(-0.045737606663228*active_layer_length + 0.00053721671440674001*ge_sio2_recomb_velocity - 0.37180434793935802*safe_sqrt_kan(0.044923674235422303 - vd_safe, sqrt_eps, smooth_delta) - 0.0216760759633743 + safe_exp_kan(-4.8748662427598502e+17*sqr(-trap_assisted_recomb_A - 7.1828801133480402e-10)) - 0.14561379761209201*safe_exp_kan(-857.41501497266904*sqr(1 - 0.0018567486108185*ge_si_recomb_velocity))) - 0.00033335653380208401*safe_exp_kan(3.6177860021574602/(1.6393993436840399 - 2.4126139874324499*vd_safe)) - 3.2792754852111701 + 0.0067018922785369202*safe_exp_kan(-66.818902613228005*sqr(1 - 0.0020714521177533501*ge_si_recomb_velocity)) - 0.0026411763734831002*safe_exp_kan(-60.018853214265597*sqr(1 - 0.027810014060302601*active_layer_length)) - 0.0155001826294954/(1.45147908539154 - 0.834053906830449*vd_safe)), smooth_delta);
    dc_current = area * (dark_current + light_power * photo_current);

    q_terminal = area * terminal_charge_model(vd_safe, trap_assisted_recomb_A, ge_sio2_recomb_velocity,
                                                     ge_si_recomb_velocity, active_layer_length, sim_temp);

    I(anode, cathode) <+ dc_current;
    I(anode, cathode) <+ ddt(q_terminal);
  end

endmodule
